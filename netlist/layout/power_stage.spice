* NGSPICE file created from power_stage.ext - technology: gf180mcuD

.subckt pfet_05v0_WX3F8K a_n968_n7788# a_n52_1232# a_n664_3464# a_52_1140# a_152_3464#
+ a_664_3372# a_n664_n5464# a_n152_n10020# a_968_n9928# a_n764_n1092# a_n868_1232#
+ a_460_n3324# a_356_1232# a_868_1140# a_n152_1140# a_n356_n3324# a_764_n3232# a_868_n7788#
+ a_764_5696# a_256_5604# a_n52_7928# a_664_n1092# a_968_3464# a_n764_3372# a_52_7836#
+ a_n1056_3464# a_n764_n7788# a_n1056_n1000# a_256_n3324# a_52_n1092# a_n968_1140#
+ a_n868_7928# a_356_7928# a_868_7836# a_n152_7836# a_n460_n5464# a_764_n9928# a_n560_n1092#
+ a_560_1232# a_n356_5604# a_n152_n3324# a_560_n3232# a_664_n7788# a_968_n7696# a_460_5604#
+ a_n256_n5464# a_52_n7788# a_460_n1092# a_n968_7836# a_n356_n1092# a_n560_n7788#
+ a_n256_3464# a_n52_n5464# a_256_3372# a_n52_5696# a_356_n3232# a_560_7928# a_560_n9928#
+ a_n868_n3232# a_256_n1092# a_n560_5604# a_356_5696# a_n868_5696# a_460_n7788# a_n356_n7788#
+ a_764_n7696# a_n764_n10020# a_968_n1000# a_n356_3372# a_356_n9928# a_n152_n1092#
+ a_n460_3464# a_460_3372# a_152_n3232# a_256_n7788# a_n868_n9928# a_n968_n5556# a_n1056_n5464#
+ a_152_1232# a_n664_1232# a_664_1140# a_n664_n3232# a_560_5696# a_n152_n7788# a_560_n7696#
+ a_764_n1000# a_868_n5556# a_764_3464# a_n560_3372# a_152_n9928# a_968_1232# a_n764_1140#
+ a_664_n10020# a_52_5604# a_152_7928# a_n664_7928# a_664_7836# a_n664_n9928# a_n764_n5556#
+ a_n1056_1232# a_356_n7696# a_868_5604# a_n152_5604# a_n460_n3232# a_n868_n7696#
+ a_n356_n10020# a_560_n1000# a_664_n5556# a_968_7928# a_n764_7836# a_968_n5464# a_n1056_7928#
+ a_52_n5556# a_n968_5604# a_n256_n3232# a_n460_n9928# a_n560_n5556# a_152_n7696#
+ a_n52_n3232# a_n256_1232# a_256_1140# a_n52_3464# a_356_n1000# a_152_5696# a_n664_5696#
+ a_52_n10020# a_52_3372# a_n664_n7696# a_n868_n1000# a_356_3464# a_n868_3464# a_868_3372#
+ a_n152_3372# a_460_n5556# a_n356_n5556# a_764_n5464# a_n256_n9928# a_n356_1140#
+ a_n52_n9928# a_n256_7928# a_256_7836# a_256_n10020# a_968_5696# a_n460_1232# a_460_1140#
+ a_n1056_5696# a_152_n1000# a_n1056_n3232# a_256_n5556# a_n968_3372# a_n968_n3324#
+ a_n460_n7696# a_n664_n1000# a_n356_7836# a_560_3464# a_n152_n5556# a_560_n5464#
+ a_n560_n10020# a_n968_n10020# a_868_n3324# a_764_1232# a_n560_1140# a_n460_7928#
+ a_460_7836# a_n256_n7696# a_n1056_n9928# a_664_5604# a_n52_n7696# a_n256_5696# a_n764_n3324#
+ a_356_n5464# w_n1232_n10184# a_n460_n1000# a_n868_n5464# a_764_7928# a_n560_7836#
+ a_n968_n1092# a_664_n3324# a_n764_5604# a_968_n3232# a_52_n3324# a_n256_n1000# a_460_n10020#
+ a_868_n1092# a_n460_5696# a_n560_n3324# a_n52_n1000# a_152_n5464# a_n1056_n7696#
+ a_868_n10020#
X0 a_n256_3464# a_n356_3372# a_n460_3464# w_n1232_n10184# pfet_05v0 ad=2.6p pd=10.52u as=2.6p ps=10.52u w=10u l=0.5u
X1 a_356_1232# a_256_1140# a_152_1232# w_n1232_n10184# pfet_05v0 ad=2.6p pd=10.52u as=2.6p ps=10.52u w=10u l=0.5u
X2 a_n664_n5464# a_n764_n5556# a_n868_n5464# w_n1232_n10184# pfet_05v0 ad=2.6p pd=10.52u as=2.6p ps=10.52u w=10u l=0.5u
X3 a_n256_n5464# a_n356_n5556# a_n460_n5464# w_n1232_n10184# pfet_05v0 ad=2.6p pd=10.52u as=2.6p ps=10.52u w=10u l=0.5u
X4 a_n256_5696# a_n356_5604# a_n460_5696# w_n1232_n10184# pfet_05v0 ad=2.6p pd=10.52u as=2.6p ps=10.52u w=10u l=0.5u
X5 a_356_3464# a_256_3372# a_152_3464# w_n1232_n10184# pfet_05v0 ad=2.6p pd=10.52u as=2.6p ps=10.52u w=10u l=0.5u
X6 a_n664_n7696# a_n764_n7788# a_n868_n7696# w_n1232_n10184# pfet_05v0 ad=2.6p pd=10.52u as=2.6p ps=10.52u w=10u l=0.5u
X7 a_n256_n7696# a_n356_n7788# a_n460_n7696# w_n1232_n10184# pfet_05v0 ad=2.6p pd=10.52u as=2.6p ps=10.52u w=10u l=0.5u
X8 a_560_n9928# a_460_n10020# a_356_n9928# w_n1232_n10184# pfet_05v0 ad=2.6p pd=10.52u as=2.6p ps=10.52u w=10u l=0.5u
X9 a_n664_7928# a_n764_7836# a_n868_7928# w_n1232_n10184# pfet_05v0 ad=2.6p pd=10.52u as=2.6p ps=10.52u w=10u l=0.5u
X10 a_560_n3232# a_460_n3324# a_356_n3232# w_n1232_n10184# pfet_05v0 ad=2.6p pd=10.52u as=2.6p ps=10.52u w=10u l=0.5u
X11 a_152_7928# a_52_7836# a_n52_7928# w_n1232_n10184# pfet_05v0 ad=2.6p pd=10.52u as=2.6p ps=10.52u w=10u l=0.5u
X12 a_356_5696# a_256_5604# a_152_5696# w_n1232_n10184# pfet_05v0 ad=2.6p pd=10.52u as=2.6p ps=10.52u w=10u l=0.5u
X13 a_n664_1232# a_n764_1140# a_n868_1232# w_n1232_n10184# pfet_05v0 ad=2.6p pd=10.52u as=2.6p ps=10.52u w=10u l=0.5u
X14 a_n868_n1000# a_n968_n1092# a_n1056_n1000# w_n1232_n10184# pfet_05v0 ad=2.6p pd=10.52u as=4.4p ps=20.88u w=10u l=0.5u
X15 a_152_1232# a_52_1140# a_n52_1232# w_n1232_n10184# pfet_05v0 ad=2.6p pd=10.52u as=2.6p ps=10.52u w=10u l=0.5u
X16 a_560_n5464# a_460_n5556# a_356_n5464# w_n1232_n10184# pfet_05v0 ad=2.6p pd=10.52u as=2.6p ps=10.52u w=10u l=0.5u
X17 a_764_7928# a_664_7836# a_560_7928# w_n1232_n10184# pfet_05v0 ad=2.6p pd=10.52u as=2.6p ps=10.52u w=10u l=0.5u
X18 a_n664_3464# a_n764_3372# a_n868_3464# w_n1232_n10184# pfet_05v0 ad=2.6p pd=10.52u as=2.6p ps=10.52u w=10u l=0.5u
X19 a_152_3464# a_52_3372# a_n52_3464# w_n1232_n10184# pfet_05v0 ad=2.6p pd=10.52u as=2.6p ps=10.52u w=10u l=0.5u
X20 a_764_1232# a_664_1140# a_560_1232# w_n1232_n10184# pfet_05v0 ad=2.6p pd=10.52u as=2.6p ps=10.52u w=10u l=0.5u
X21 a_968_n1000# a_868_n1092# a_764_n1000# w_n1232_n10184# pfet_05v0 ad=4.4p pd=20.88u as=2.6p ps=10.52u w=10u l=0.5u
X22 a_560_n7696# a_460_n7788# a_356_n7696# w_n1232_n10184# pfet_05v0 ad=2.6p pd=10.52u as=2.6p ps=10.52u w=10u l=0.5u
X23 a_560_n1000# a_460_n1092# a_356_n1000# w_n1232_n10184# pfet_05v0 ad=2.6p pd=10.52u as=2.6p ps=10.52u w=10u l=0.5u
X24 a_n664_5696# a_n764_5604# a_n868_5696# w_n1232_n10184# pfet_05v0 ad=2.6p pd=10.52u as=2.6p ps=10.52u w=10u l=0.5u
X25 a_152_5696# a_52_5604# a_n52_5696# w_n1232_n10184# pfet_05v0 ad=2.6p pd=10.52u as=2.6p ps=10.52u w=10u l=0.5u
X26 a_764_3464# a_664_3372# a_560_3464# w_n1232_n10184# pfet_05v0 ad=2.6p pd=10.52u as=2.6p ps=10.52u w=10u l=0.5u
X27 a_n52_n3232# a_n152_n3324# a_n256_n3232# w_n1232_n10184# pfet_05v0 ad=2.6p pd=10.52u as=2.6p ps=10.52u w=10u l=0.5u
X28 a_n52_n9928# a_n152_n10020# a_n256_n9928# w_n1232_n10184# pfet_05v0 ad=2.6p pd=10.52u as=2.6p ps=10.52u w=10u l=0.5u
X29 a_968_n9928# a_868_n10020# a_764_n9928# w_n1232_n10184# pfet_05v0 ad=4.4p pd=20.88u as=2.6p ps=10.52u w=10u l=0.5u
X30 a_n460_7928# a_n560_7836# a_n664_7928# w_n1232_n10184# pfet_05v0 ad=2.6p pd=10.52u as=2.6p ps=10.52u w=10u l=0.5u
X31 a_764_5696# a_664_5604# a_560_5696# w_n1232_n10184# pfet_05v0 ad=2.6p pd=10.52u as=2.6p ps=10.52u w=10u l=0.5u
X32 a_968_n3232# a_868_n3324# a_764_n3232# w_n1232_n10184# pfet_05v0 ad=4.4p pd=20.88u as=2.6p ps=10.52u w=10u l=0.5u
X33 a_n52_7928# a_n152_7836# a_n256_7928# w_n1232_n10184# pfet_05v0 ad=2.6p pd=10.52u as=2.6p ps=10.52u w=10u l=0.5u
X34 a_n460_1232# a_n560_1140# a_n664_1232# w_n1232_n10184# pfet_05v0 ad=2.6p pd=10.52u as=2.6p ps=10.52u w=10u l=0.5u
X35 a_n52_n5464# a_n152_n5556# a_n256_n5464# w_n1232_n10184# pfet_05v0 ad=2.6p pd=10.52u as=2.6p ps=10.52u w=10u l=0.5u
X36 a_n52_1232# a_n152_1140# a_n256_1232# w_n1232_n10184# pfet_05v0 ad=2.6p pd=10.52u as=2.6p ps=10.52u w=10u l=0.5u
X37 a_n256_n1000# a_n356_n1092# a_n460_n1000# w_n1232_n10184# pfet_05v0 ad=2.6p pd=10.52u as=2.6p ps=10.52u w=10u l=0.5u
X38 a_968_n5464# a_868_n5556# a_764_n5464# w_n1232_n10184# pfet_05v0 ad=4.4p pd=20.88u as=2.6p ps=10.52u w=10u l=0.5u
X39 a_n460_3464# a_n560_3372# a_n664_3464# w_n1232_n10184# pfet_05v0 ad=2.6p pd=10.52u as=2.6p ps=10.52u w=10u l=0.5u
X40 a_n52_n7696# a_n152_n7788# a_n256_n7696# w_n1232_n10184# pfet_05v0 ad=2.6p pd=10.52u as=2.6p ps=10.52u w=10u l=0.5u
X41 a_152_n9928# a_52_n10020# a_n52_n9928# w_n1232_n10184# pfet_05v0 ad=2.6p pd=10.52u as=2.6p ps=10.52u w=10u l=0.5u
X42 a_n52_3464# a_n152_3372# a_n256_3464# w_n1232_n10184# pfet_05v0 ad=2.6p pd=10.52u as=2.6p ps=10.52u w=10u l=0.5u
X43 a_152_n3232# a_52_n3324# a_n52_n3232# w_n1232_n10184# pfet_05v0 ad=2.6p pd=10.52u as=2.6p ps=10.52u w=10u l=0.5u
X44 a_968_n7696# a_868_n7788# a_764_n7696# w_n1232_n10184# pfet_05v0 ad=4.4p pd=20.88u as=2.6p ps=10.52u w=10u l=0.5u
X45 a_356_n1000# a_256_n1092# a_152_n1000# w_n1232_n10184# pfet_05v0 ad=2.6p pd=10.52u as=2.6p ps=10.52u w=10u l=0.5u
X46 a_n868_n9928# a_n968_n10020# a_n1056_n9928# w_n1232_n10184# pfet_05v0 ad=2.6p pd=10.52u as=4.4p ps=20.88u w=10u l=0.5u
X47 a_n460_n9928# a_n560_n10020# a_n664_n9928# w_n1232_n10184# pfet_05v0 ad=2.6p pd=10.52u as=2.6p ps=10.52u w=10u l=0.5u
X48 a_n460_5696# a_n560_5604# a_n664_5696# w_n1232_n10184# pfet_05v0 ad=2.6p pd=10.52u as=2.6p ps=10.52u w=10u l=0.5u
X49 a_n52_5696# a_n152_5604# a_n256_5696# w_n1232_n10184# pfet_05v0 ad=2.6p pd=10.52u as=2.6p ps=10.52u w=10u l=0.5u
X50 a_n868_n3232# a_n968_n3324# a_n1056_n3232# w_n1232_n10184# pfet_05v0 ad=2.6p pd=10.52u as=4.4p ps=20.88u w=10u l=0.5u
X51 a_n460_n3232# a_n560_n3324# a_n664_n3232# w_n1232_n10184# pfet_05v0 ad=2.6p pd=10.52u as=2.6p ps=10.52u w=10u l=0.5u
X52 a_152_n5464# a_52_n5556# a_n52_n5464# w_n1232_n10184# pfet_05v0 ad=2.6p pd=10.52u as=2.6p ps=10.52u w=10u l=0.5u
X53 a_n868_7928# a_n968_7836# a_n1056_7928# w_n1232_n10184# pfet_05v0 ad=2.6p pd=10.52u as=4.4p ps=20.88u w=10u l=0.5u
X54 a_n868_n5464# a_n968_n5556# a_n1056_n5464# w_n1232_n10184# pfet_05v0 ad=2.6p pd=10.52u as=4.4p ps=20.88u w=10u l=0.5u
X55 a_n460_n5464# a_n560_n5556# a_n664_n5464# w_n1232_n10184# pfet_05v0 ad=2.6p pd=10.52u as=2.6p ps=10.52u w=10u l=0.5u
X56 a_152_n7696# a_52_n7788# a_n52_n7696# w_n1232_n10184# pfet_05v0 ad=2.6p pd=10.52u as=2.6p ps=10.52u w=10u l=0.5u
X57 a_n868_1232# a_n968_1140# a_n1056_1232# w_n1232_n10184# pfet_05v0 ad=2.6p pd=10.52u as=4.4p ps=20.88u w=10u l=0.5u
X58 a_968_7928# a_868_7836# a_764_7928# w_n1232_n10184# pfet_05v0 ad=4.4p pd=20.88u as=2.6p ps=10.52u w=10u l=0.5u
X59 a_n664_n1000# a_n764_n1092# a_n868_n1000# w_n1232_n10184# pfet_05v0 ad=2.6p pd=10.52u as=2.6p ps=10.52u w=10u l=0.5u
X60 a_152_n1000# a_52_n1092# a_n52_n1000# w_n1232_n10184# pfet_05v0 ad=2.6p pd=10.52u as=2.6p ps=10.52u w=10u l=0.5u
X61 a_n868_n7696# a_n968_n7788# a_n1056_n7696# w_n1232_n10184# pfet_05v0 ad=2.6p pd=10.52u as=4.4p ps=20.88u w=10u l=0.5u
X62 a_560_7928# a_460_7836# a_356_7928# w_n1232_n10184# pfet_05v0 ad=2.6p pd=10.52u as=2.6p ps=10.52u w=10u l=0.5u
X63 a_n868_3464# a_n968_3372# a_n1056_3464# w_n1232_n10184# pfet_05v0 ad=2.6p pd=10.52u as=4.4p ps=20.88u w=10u l=0.5u
X64 a_968_1232# a_868_1140# a_764_1232# w_n1232_n10184# pfet_05v0 ad=4.4p pd=20.88u as=2.6p ps=10.52u w=10u l=0.5u
X65 a_n460_n7696# a_n560_n7788# a_n664_n7696# w_n1232_n10184# pfet_05v0 ad=2.6p pd=10.52u as=2.6p ps=10.52u w=10u l=0.5u
X66 a_356_n9928# a_256_n10020# a_152_n9928# w_n1232_n10184# pfet_05v0 ad=2.6p pd=10.52u as=2.6p ps=10.52u w=10u l=0.5u
X67 a_764_n9928# a_664_n10020# a_560_n9928# w_n1232_n10184# pfet_05v0 ad=2.6p pd=10.52u as=2.6p ps=10.52u w=10u l=0.5u
X68 a_560_1232# a_460_1140# a_356_1232# w_n1232_n10184# pfet_05v0 ad=2.6p pd=10.52u as=2.6p ps=10.52u w=10u l=0.5u
X69 a_764_n1000# a_664_n1092# a_560_n1000# w_n1232_n10184# pfet_05v0 ad=2.6p pd=10.52u as=2.6p ps=10.52u w=10u l=0.5u
X70 a_356_n3232# a_256_n3324# a_152_n3232# w_n1232_n10184# pfet_05v0 ad=2.6p pd=10.52u as=2.6p ps=10.52u w=10u l=0.5u
X71 a_764_n3232# a_664_n3324# a_560_n3232# w_n1232_n10184# pfet_05v0 ad=2.6p pd=10.52u as=2.6p ps=10.52u w=10u l=0.5u
X72 a_n868_5696# a_n968_5604# a_n1056_5696# w_n1232_n10184# pfet_05v0 ad=2.6p pd=10.52u as=4.4p ps=20.88u w=10u l=0.5u
X73 a_560_3464# a_460_3372# a_356_3464# w_n1232_n10184# pfet_05v0 ad=2.6p pd=10.52u as=2.6p ps=10.52u w=10u l=0.5u
X74 a_968_3464# a_868_3372# a_764_3464# w_n1232_n10184# pfet_05v0 ad=4.4p pd=20.88u as=2.6p ps=10.52u w=10u l=0.5u
X75 a_356_n5464# a_256_n5556# a_152_n5464# w_n1232_n10184# pfet_05v0 ad=2.6p pd=10.52u as=2.6p ps=10.52u w=10u l=0.5u
X76 a_764_n5464# a_664_n5556# a_560_n5464# w_n1232_n10184# pfet_05v0 ad=2.6p pd=10.52u as=2.6p ps=10.52u w=10u l=0.5u
X77 a_968_5696# a_868_5604# a_764_5696# w_n1232_n10184# pfet_05v0 ad=4.4p pd=20.88u as=2.6p ps=10.52u w=10u l=0.5u
X78 a_356_n7696# a_256_n7788# a_152_n7696# w_n1232_n10184# pfet_05v0 ad=2.6p pd=10.52u as=2.6p ps=10.52u w=10u l=0.5u
X79 a_764_n7696# a_664_n7788# a_560_n7696# w_n1232_n10184# pfet_05v0 ad=2.6p pd=10.52u as=2.6p ps=10.52u w=10u l=0.5u
X80 a_n256_7928# a_n356_7836# a_n460_7928# w_n1232_n10184# pfet_05v0 ad=2.6p pd=10.52u as=2.6p ps=10.52u w=10u l=0.5u
X81 a_560_5696# a_460_5604# a_356_5696# w_n1232_n10184# pfet_05v0 ad=2.6p pd=10.52u as=2.6p ps=10.52u w=10u l=0.5u
X82 a_n256_1232# a_n356_1140# a_n460_1232# w_n1232_n10184# pfet_05v0 ad=2.6p pd=10.52u as=2.6p ps=10.52u w=10u l=0.5u
X83 a_n664_n9928# a_n764_n10020# a_n868_n9928# w_n1232_n10184# pfet_05v0 ad=2.6p pd=10.52u as=2.6p ps=10.52u w=10u l=0.5u
X84 a_n256_n9928# a_n356_n10020# a_n460_n9928# w_n1232_n10184# pfet_05v0 ad=2.6p pd=10.52u as=2.6p ps=10.52u w=10u l=0.5u
X85 a_n460_n1000# a_n560_n1092# a_n664_n1000# w_n1232_n10184# pfet_05v0 ad=2.6p pd=10.52u as=2.6p ps=10.52u w=10u l=0.5u
X86 a_n52_n1000# a_n152_n1092# a_n256_n1000# w_n1232_n10184# pfet_05v0 ad=2.6p pd=10.52u as=2.6p ps=10.52u w=10u l=0.5u
X87 a_n664_n3232# a_n764_n3324# a_n868_n3232# w_n1232_n10184# pfet_05v0 ad=2.6p pd=10.52u as=2.6p ps=10.52u w=10u l=0.5u
X88 a_n256_n3232# a_n356_n3324# a_n460_n3232# w_n1232_n10184# pfet_05v0 ad=2.6p pd=10.52u as=2.6p ps=10.52u w=10u l=0.5u
X89 a_356_7928# a_256_7836# a_152_7928# w_n1232_n10184# pfet_05v0 ad=2.6p pd=10.52u as=2.6p ps=10.52u w=10u l=0.5u
.ends

.subckt gf180mcu_as_sc_mcu7t3v3__fillcap_4 VDD VNW VPW VSS
X0 a_126_408# a_28_500# VSS VPW nfet_03v3 ad=0.44p pd=2.88u as=0.49p ps=2.98u w=1u l=1.03u
X1 VDD a_126_408# a_28_500# VNW pfet_03v3 ad=0.4752p pd=3.04u as=0.5292p ps=3.14u w=1.08u l=1.03u
.ends

.subckt gf180mcu_as_sc_mcu7t3v3__inv_4 VDD VNW VPW VSS Y A
X0 VDD A Y VNW pfet_03v3 ad=0.3588p pd=1.9u as=0.3588p ps=1.9u w=1.38u l=0.28u
X1 Y A VSS VPW nfet_03v3 ad=0.26p pd=1.52u as=0.44p ps=2.88u w=1u l=0.28u
X2 Y A VDD VNW pfet_03v3 ad=0.3588p pd=1.9u as=0.3588p ps=1.9u w=1.38u l=0.28u
X3 VSS A Y VPW nfet_03v3 ad=0.52p pd=3.04u as=0.26p ps=1.52u w=1u l=0.28u
X4 VDD A Y VNW pfet_03v3 ad=0.7176p pd=3.8u as=0.3588p ps=1.9u w=1.38u l=0.28u
X5 Y A VSS VPW nfet_03v3 ad=0.26p pd=1.52u as=0.26p ps=1.52u w=1u l=0.28u
X6 Y A VDD VNW pfet_03v3 ad=0.3588p pd=1.9u as=0.6072p ps=3.64u w=1.38u l=0.28u
X7 VSS A Y VPW nfet_03v3 ad=0.26p pd=1.52u as=0.26p ps=1.52u w=1u l=0.28u
.ends

.subckt gf180mcu_as_sc_mcu7t3v3__diode_2 VDD VNW VPW VSS DIODE
D0 DIODE VNW diode_pd2nw_03v3 pj=1.93u area=0.2295p
D1 VPW DIODE diode_nd2ps_03v3 pj=1.83u area=0.209p
.ends

.subckt nfet_05v0_BJME2D a_n52_n500# a_3412_n592# a_2068_n592# a_3980_n500# a_9356_n500#
+ a_n5204_n500# a_7668_n592# a_n4876_n592# a_172_n500# a_2636_n500# a_n500_n500# a_3860_n592#
+ a_9236_n592# a_n6444_n592# a_n9892_n500# a_n5652_n500# a_4204_n500# a_4084_n592#
+ a_2516_n592# a_n1292_n592# a_n396_n592# a_n8012_n592# a_n7220_n500# a_n4308_n500#
+ a_9804_n500# a_9684_n592# a_620_n500# a_n6892_n592# a_4652_n500# a_52_n592# a_2964_n592#
+ a_n5548_n592# a_n8460_n592# a_n4756_n500# a_3308_n500# a_6220_n500# a_500_n592#
+ a_4532_n592# a_3188_n592# a_n1740_n592# a_8908_n500# a_n844_n592# a_n7116_n592#
+ a_n6324_n500# a_8788_n592# a_6100_n592# a_n5996_n592# a_3756_n500# a_n1172_n500#
+ a_n276_n500# a_4980_n592# a_n7564_n592# a_n6772_n500# a_5324_n500# a_3636_n592#
+ a_n9132_n592# a_n8340_n500# a_n5428_n500# a_396_n500# a_5204_n592# a_n1068_n592#
+ a_n2412_n592# a_5772_n500# a_n1620_n500# a_n724_n500# a_n6668_n592# a_n9580_n592#
+ a_n5876_n500# a_4428_n500# a_7340_n500# a_276_n592# a_5652_n592# a_n2860_n592# a_n8236_n592#
+ a_n7444_n500# a_844_n500# a_4876_n500# a_7220_n592# a_4308_n592# a_n1516_n592# a_n3084_n592#
+ a_n2292_n500# a_n9012_n500# a_n8684_n592# a_n7892_n500# a_6444_n500# a_724_n592#
+ a_4756_n592# a_n1964_n592# a_1292_n500# a_n9460_n500# a_n6548_n500# a_8012_n500#
+ a_6324_n592# a_6892_n500# a_n2188_n592# a_n3532_n592# a_n2740_n500# a_n1396_n500#
+ a_n8116_n500# a_1172_n592# a_n7788_n592# a_n6996_n500# a_5548_n500# a_8460_n500#
+ a_n5100_n592# a_6772_n592# a_n3980_n592# a_1740_n500# a_n9356_n592# a_n8564_n500#
+ a_7116_n500# a_8340_n592# a_5428_n592# a_n2636_n592# a_5996_n500# a_n1844_n500#
+ a_n948_n500# a_1620_n592# a_n4204_n592# a_n2068_n500# a_7564_n500# a_n3412_n500#
+ a_5876_n592# a_n9804_n592# a_n7668_n500# a_9132_n500# a_7444_n592# a_n4652_n592#
+ a_n3860_n500# a_n9236_n500# a_1068_n500# a_2412_n500# a_2292_n592# a_9012_n592#
+ a_n3308_n592# a_n6220_n592# a_n4084_n500# a_n2516_n500# a_6668_n500# a_9580_n500#
+ a_948_n592# a_7892_n592# a_2860_n500# a_n8908_n592# a_n9684_n500# a_n172_n592# a_8236_n500#
+ a_9460_n592# a_6548_n592# a_n3756_n592# a_n2964_n500# a_1516_n500# a_3084_n500#
+ a_2740_n592# a_1396_n592# a_8116_n592# a_8684_n500# a_n5324_n592# a_n4532_n500#
+ a_n3188_n500# a_6996_n592# a_1964_n500# a_n8788_n500# a_n620_n592# a_n6100_n500#
+ a_8564_n592# a_n5772_n592# a_n4980_n500# a_2188_n500# a_3532_n500# a_1844_n592#
+ a_n4428_n592# a_n7340_n592# a_7788_n500# VSUBS a_n3636_n500# a_5100_n500#
X0 a_3084_n500# a_2964_n592# a_2860_n500# VSUBS nfet_05v0 ad=1.3p pd=5.52u as=1.3p ps=5.52u w=5u l=0.6u
X1 a_1740_n500# a_1620_n592# a_1516_n500# VSUBS nfet_05v0 ad=1.3p pd=5.52u as=1.3p ps=5.52u w=5u l=0.6u
X2 a_3756_n500# a_3636_n592# a_3532_n500# VSUBS nfet_05v0 ad=1.3p pd=5.52u as=1.3p ps=5.52u w=5u l=0.6u
X3 a_4428_n500# a_4308_n592# a_4204_n500# VSUBS nfet_05v0 ad=1.3p pd=5.52u as=1.3p ps=5.52u w=5u l=0.6u
X4 a_2860_n500# a_2740_n592# a_2636_n500# VSUBS nfet_05v0 ad=1.3p pd=5.52u as=1.3p ps=5.52u w=5u l=0.6u
X5 a_4876_n500# a_4756_n592# a_4652_n500# VSUBS nfet_05v0 ad=1.3p pd=5.52u as=1.3p ps=5.52u w=5u l=0.6u
X6 a_1068_n500# a_948_n592# a_844_n500# VSUBS nfet_05v0 ad=1.3p pd=5.52u as=1.3p ps=5.52u w=5u l=0.6u
X7 a_1516_n500# a_1396_n592# a_1292_n500# VSUBS nfet_05v0 ad=1.3p pd=5.52u as=1.3p ps=5.52u w=5u l=0.6u
X8 a_3532_n500# a_3412_n592# a_3308_n500# VSUBS nfet_05v0 ad=1.3p pd=5.52u as=1.3p ps=5.52u w=5u l=0.6u
X9 a_5548_n500# a_5428_n592# a_5324_n500# VSUBS nfet_05v0 ad=1.3p pd=5.52u as=1.3p ps=5.52u w=5u l=0.6u
X10 a_2188_n500# a_2068_n592# a_1964_n500# VSUBS nfet_05v0 ad=1.3p pd=5.52u as=1.3p ps=5.52u w=5u l=0.6u
X11 a_5996_n500# a_5876_n592# a_5772_n500# VSUBS nfet_05v0 ad=1.3p pd=5.52u as=1.3p ps=5.52u w=5u l=0.6u
X12 a_n1620_n500# a_n1740_n592# a_n1844_n500# VSUBS nfet_05v0 ad=1.3p pd=5.52u as=1.3p ps=5.52u w=5u l=0.6u
X13 a_3980_n500# a_3860_n592# a_3756_n500# VSUBS nfet_05v0 ad=1.3p pd=5.52u as=1.3p ps=5.52u w=5u l=0.6u
X14 a_4652_n500# a_4532_n592# a_4428_n500# VSUBS nfet_05v0 ad=1.3p pd=5.52u as=1.3p ps=5.52u w=5u l=0.6u
X15 a_6668_n500# a_6548_n592# a_6444_n500# VSUBS nfet_05v0 ad=1.3p pd=5.52u as=1.3p ps=5.52u w=5u l=0.6u
X16 a_172_n500# a_52_n592# a_n52_n500# VSUBS nfet_05v0 ad=1.3p pd=5.52u as=1.3p ps=5.52u w=5u l=0.6u
X17 a_844_n500# a_724_n592# a_620_n500# VSUBS nfet_05v0 ad=1.3p pd=5.52u as=1.3p ps=5.52u w=5u l=0.6u
X18 a_3308_n500# a_3188_n592# a_3084_n500# VSUBS nfet_05v0 ad=1.3p pd=5.52u as=1.3p ps=5.52u w=5u l=0.6u
X19 a_5324_n500# a_5204_n592# a_5100_n500# VSUBS nfet_05v0 ad=1.3p pd=5.52u as=1.3p ps=5.52u w=5u l=0.6u
X20 a_7116_n500# a_6996_n592# a_6892_n500# VSUBS nfet_05v0 ad=1.3p pd=5.52u as=1.3p ps=5.52u w=5u l=0.6u
X21 a_n2740_n500# a_n2860_n592# a_n2964_n500# VSUBS nfet_05v0 ad=1.3p pd=5.52u as=1.3p ps=5.52u w=5u l=0.6u
X22 a_1292_n500# a_1172_n592# a_1068_n500# VSUBS nfet_05v0 ad=1.3p pd=5.52u as=1.3p ps=5.52u w=5u l=0.6u
X23 a_5100_n500# a_4980_n592# a_4876_n500# VSUBS nfet_05v0 ad=1.3p pd=5.52u as=1.3p ps=5.52u w=5u l=0.6u
X24 a_5772_n500# a_5652_n592# a_5548_n500# VSUBS nfet_05v0 ad=1.3p pd=5.52u as=1.3p ps=5.52u w=5u l=0.6u
X25 a_7788_n500# a_7668_n592# a_7564_n500# VSUBS nfet_05v0 ad=1.3p pd=5.52u as=1.3p ps=5.52u w=5u l=0.6u
X26 a_n1396_n500# a_n1516_n592# a_n1620_n500# VSUBS nfet_05v0 ad=1.3p pd=5.52u as=1.3p ps=5.52u w=5u l=0.6u
X27 a_6444_n500# a_6324_n592# a_6220_n500# VSUBS nfet_05v0 ad=1.3p pd=5.52u as=1.3p ps=5.52u w=5u l=0.6u
X28 a_n3860_n500# a_n3980_n592# a_n4084_n500# VSUBS nfet_05v0 ad=1.3p pd=5.52u as=1.3p ps=5.52u w=5u l=0.6u
X29 a_2412_n500# a_2292_n592# a_2188_n500# VSUBS nfet_05v0 ad=1.3p pd=5.52u as=1.3p ps=5.52u w=5u l=0.6u
X30 a_8908_n500# a_8788_n592# a_8684_n500# VSUBS nfet_05v0 ad=1.3p pd=5.52u as=1.3p ps=5.52u w=5u l=0.6u
X31 a_n1844_n500# a_n1964_n592# a_n2068_n500# VSUBS nfet_05v0 ad=1.3p pd=5.52u as=1.3p ps=5.52u w=5u l=0.6u
X32 a_620_n500# a_500_n592# a_396_n500# VSUBS nfet_05v0 ad=1.3p pd=5.52u as=1.3p ps=5.52u w=5u l=0.6u
X33 a_6892_n500# a_6772_n592# a_6668_n500# VSUBS nfet_05v0 ad=1.3p pd=5.52u as=1.3p ps=5.52u w=5u l=0.6u
X34 a_7564_n500# a_7444_n592# a_7340_n500# VSUBS nfet_05v0 ad=1.3p pd=5.52u as=1.3p ps=5.52u w=5u l=0.6u
X35 a_n3188_n500# a_n3308_n592# a_n3412_n500# VSUBS nfet_05v0 ad=1.3p pd=5.52u as=1.3p ps=5.52u w=5u l=0.6u
X36 a_n2516_n500# a_n2636_n592# a_n2740_n500# VSUBS nfet_05v0 ad=1.3p pd=5.52u as=1.3p ps=5.52u w=5u l=0.6u
X37 a_8236_n500# a_8116_n592# a_8012_n500# VSUBS nfet_05v0 ad=1.3p pd=5.52u as=1.3p ps=5.52u w=5u l=0.6u
X38 a_n500_n500# a_n620_n592# a_n724_n500# VSUBS nfet_05v0 ad=1.3p pd=5.52u as=1.3p ps=5.52u w=5u l=0.6u
X39 a_4204_n500# a_4084_n592# a_3980_n500# VSUBS nfet_05v0 ad=1.3p pd=5.52u as=1.3p ps=5.52u w=5u l=0.6u
X40 a_6220_n500# a_6100_n592# a_5996_n500# VSUBS nfet_05v0 ad=1.3p pd=5.52u as=1.3p ps=5.52u w=5u l=0.6u
X41 a_8012_n500# a_7892_n592# a_7788_n500# VSUBS nfet_05v0 ad=1.3p pd=5.52u as=1.3p ps=5.52u w=5u l=0.6u
X42 a_n4308_n500# a_n4428_n592# a_n4532_n500# VSUBS nfet_05v0 ad=1.3p pd=5.52u as=1.3p ps=5.52u w=5u l=0.6u
X43 a_n3636_n500# a_n3756_n592# a_n3860_n500# VSUBS nfet_05v0 ad=1.3p pd=5.52u as=1.3p ps=5.52u w=5u l=0.6u
X44 a_396_n500# a_276_n592# a_172_n500# VSUBS nfet_05v0 ad=1.3p pd=5.52u as=1.3p ps=5.52u w=5u l=0.6u
X45 a_8684_n500# a_8564_n592# a_8460_n500# VSUBS nfet_05v0 ad=1.3p pd=5.52u as=1.3p ps=5.52u w=5u l=0.6u
X46 a_9356_n500# a_9236_n592# a_9132_n500# VSUBS nfet_05v0 ad=1.3p pd=5.52u as=1.3p ps=5.52u w=5u l=0.6u
X47 a_n8788_n500# a_n8908_n592# a_n9012_n500# VSUBS nfet_05v0 ad=1.3p pd=5.52u as=1.3p ps=5.52u w=5u l=0.6u
X48 a_n2292_n500# a_n2412_n592# a_n2516_n500# VSUBS nfet_05v0 ad=1.3p pd=5.52u as=1.3p ps=5.52u w=5u l=0.6u
X49 a_7340_n500# a_7220_n592# a_7116_n500# VSUBS nfet_05v0 ad=1.3p pd=5.52u as=1.3p ps=5.52u w=5u l=0.6u
X50 a_n4756_n500# a_n4876_n592# a_n4980_n500# VSUBS nfet_05v0 ad=1.3p pd=5.52u as=1.3p ps=5.52u w=5u l=0.6u
X51 a_n948_n500# a_n1068_n592# a_n1172_n500# VSUBS nfet_05v0 ad=1.3p pd=5.52u as=1.3p ps=5.52u w=5u l=0.6u
X52 a_9804_n500# a_9684_n592# a_9580_n500# VSUBS nfet_05v0 ad=2.2p pd=10.88u as=1.3p ps=5.52u w=5u l=0.6u
X53 a_n6100_n500# a_n6220_n592# a_n6324_n500# VSUBS nfet_05v0 ad=1.3p pd=5.52u as=1.3p ps=5.52u w=5u l=0.6u
X54 a_n5428_n500# a_n5548_n592# a_n5652_n500# VSUBS nfet_05v0 ad=1.3p pd=5.52u as=1.3p ps=5.52u w=5u l=0.6u
X55 a_n3412_n500# a_n3532_n592# a_n3636_n500# VSUBS nfet_05v0 ad=1.3p pd=5.52u as=1.3p ps=5.52u w=5u l=0.6u
X56 a_8460_n500# a_8340_n592# a_8236_n500# VSUBS nfet_05v0 ad=1.3p pd=5.52u as=1.3p ps=5.52u w=5u l=0.6u
X57 a_n5876_n500# a_n5996_n592# a_n6100_n500# VSUBS nfet_05v0 ad=1.3p pd=5.52u as=1.3p ps=5.52u w=5u l=0.6u
X58 a_n4084_n500# a_n4204_n592# a_n4308_n500# VSUBS nfet_05v0 ad=1.3p pd=5.52u as=1.3p ps=5.52u w=5u l=0.6u
X59 a_n2068_n500# a_n2188_n592# a_n2292_n500# VSUBS nfet_05v0 ad=1.3p pd=5.52u as=1.3p ps=5.52u w=5u l=0.6u
X60 a_n724_n500# a_n844_n592# a_n948_n500# VSUBS nfet_05v0 ad=1.3p pd=5.52u as=1.3p ps=5.52u w=5u l=0.6u
X61 a_9132_n500# a_9012_n592# a_8908_n500# VSUBS nfet_05v0 ad=1.3p pd=5.52u as=1.3p ps=5.52u w=5u l=0.6u
X62 a_n6548_n500# a_n6668_n592# a_n6772_n500# VSUBS nfet_05v0 ad=1.3p pd=5.52u as=1.3p ps=5.52u w=5u l=0.6u
X63 a_n4532_n500# a_n4652_n592# a_n4756_n500# VSUBS nfet_05v0 ad=1.3p pd=5.52u as=1.3p ps=5.52u w=5u l=0.6u
X64 a_9580_n500# a_9460_n592# a_9356_n500# VSUBS nfet_05v0 ad=1.3p pd=5.52u as=1.3p ps=5.52u w=5u l=0.6u
X65 a_n7220_n500# a_n7340_n592# a_n7444_n500# VSUBS nfet_05v0 ad=1.3p pd=5.52u as=1.3p ps=5.52u w=5u l=0.6u
X66 a_n5204_n500# a_n5324_n592# a_n5428_n500# VSUBS nfet_05v0 ad=1.3p pd=5.52u as=1.3p ps=5.52u w=5u l=0.6u
X67 a_n9684_n500# a_n9804_n592# a_n9892_n500# VSUBS nfet_05v0 ad=1.3p pd=5.52u as=2.2p ps=10.88u w=5u l=0.6u
X68 a_n7668_n500# a_n7788_n592# a_n7892_n500# VSUBS nfet_05v0 ad=1.3p pd=5.52u as=1.3p ps=5.52u w=5u l=0.6u
X69 a_n5652_n500# a_n5772_n592# a_n5876_n500# VSUBS nfet_05v0 ad=1.3p pd=5.52u as=1.3p ps=5.52u w=5u l=0.6u
X70 a_n1172_n500# a_n1292_n592# a_n1396_n500# VSUBS nfet_05v0 ad=1.3p pd=5.52u as=1.3p ps=5.52u w=5u l=0.6u
X71 a_n8340_n500# a_n8460_n592# a_n8564_n500# VSUBS nfet_05v0 ad=1.3p pd=5.52u as=1.3p ps=5.52u w=5u l=0.6u
X72 a_n6324_n500# a_n6444_n592# a_n6548_n500# VSUBS nfet_05v0 ad=1.3p pd=5.52u as=1.3p ps=5.52u w=5u l=0.6u
X73 a_n6996_n500# a_n7116_n592# a_n7220_n500# VSUBS nfet_05v0 ad=1.3p pd=5.52u as=1.3p ps=5.52u w=5u l=0.6u
X74 a_n4980_n500# a_n5100_n592# a_n5204_n500# VSUBS nfet_05v0 ad=1.3p pd=5.52u as=1.3p ps=5.52u w=5u l=0.6u
X75 a_n9460_n500# a_n9580_n592# a_n9684_n500# VSUBS nfet_05v0 ad=1.3p pd=5.52u as=1.3p ps=5.52u w=5u l=0.6u
X76 a_n7444_n500# a_n7564_n592# a_n7668_n500# VSUBS nfet_05v0 ad=1.3p pd=5.52u as=1.3p ps=5.52u w=5u l=0.6u
X77 a_n6772_n500# a_n6892_n592# a_n6996_n500# VSUBS nfet_05v0 ad=1.3p pd=5.52u as=1.3p ps=5.52u w=5u l=0.6u
X78 a_n2964_n500# a_n3084_n592# a_n3188_n500# VSUBS nfet_05v0 ad=1.3p pd=5.52u as=1.3p ps=5.52u w=5u l=0.6u
X79 a_n276_n500# a_n396_n592# a_n500_n500# VSUBS nfet_05v0 ad=1.3p pd=5.52u as=1.3p ps=5.52u w=5u l=0.6u
X80 a_n8116_n500# a_n8236_n592# a_n8340_n500# VSUBS nfet_05v0 ad=1.3p pd=5.52u as=1.3p ps=5.52u w=5u l=0.6u
X81 a_n9236_n500# a_n9356_n592# a_n9460_n500# VSUBS nfet_05v0 ad=1.3p pd=5.52u as=1.3p ps=5.52u w=5u l=0.6u
X82 a_n8564_n500# a_n8684_n592# a_n8788_n500# VSUBS nfet_05v0 ad=1.3p pd=5.52u as=1.3p ps=5.52u w=5u l=0.6u
X83 a_n52_n500# a_n172_n592# a_n276_n500# VSUBS nfet_05v0 ad=1.3p pd=5.52u as=1.3p ps=5.52u w=5u l=0.6u
X84 a_n7892_n500# a_n8012_n592# a_n8116_n500# VSUBS nfet_05v0 ad=1.3p pd=5.52u as=1.3p ps=5.52u w=5u l=0.6u
X85 a_1964_n500# a_1844_n592# a_1740_n500# VSUBS nfet_05v0 ad=1.3p pd=5.52u as=1.3p ps=5.52u w=5u l=0.6u
X86 a_n9012_n500# a_n9132_n592# a_n9236_n500# VSUBS nfet_05v0 ad=1.3p pd=5.52u as=1.3p ps=5.52u w=5u l=0.6u
X87 a_2636_n500# a_2516_n592# a_2412_n500# VSUBS nfet_05v0 ad=1.3p pd=5.52u as=1.3p ps=5.52u w=5u l=0.6u
.ends

.subckt nfet_05v0_AGRLGL a_n52_n200# a_172_n200# a_n396_n292# a_52_n292# a_n276_n200#
+ a_396_n200# a_276_n292# a_n484_n200# a_n172_n292# VSUBS
X0 a_172_n200# a_52_n292# a_n52_n200# VSUBS nfet_05v0 ad=0.52p pd=2.52u as=0.52p ps=2.52u w=2u l=0.6u
X1 a_396_n200# a_276_n292# a_172_n200# VSUBS nfet_05v0 ad=0.88p pd=4.88u as=0.52p ps=2.52u w=2u l=0.6u
X2 a_n276_n200# a_n396_n292# a_n484_n200# VSUBS nfet_05v0 ad=0.52p pd=2.52u as=0.88p ps=4.88u w=2u l=0.6u
X3 a_n52_n200# a_n172_n292# a_n276_n200# VSUBS nfet_05v0 ad=0.52p pd=2.52u as=0.52p ps=2.52u w=2u l=0.6u
.ends

.subckt pfet_05v0_X3LYAZ a_n256_n76# a_n444_n76# a_356_n76# a_52_n168# a_n152_n168#
+ a_152_n76# a_n52_n76# w_n530_n254# a_256_n168# a_n356_n168#
X0 a_356_n76# a_256_n168# a_152_n76# w_n530_n254# pfet_05v0 ad=0.44p pd=2.88u as=0.26p ps=1.52u w=1u l=0.5u
X1 a_152_n76# a_52_n168# a_n52_n76# w_n530_n254# pfet_05v0 ad=0.26p pd=1.52u as=0.26p ps=1.52u w=1u l=0.5u
X2 a_n52_n76# a_n152_n168# a_n256_n76# w_n530_n254# pfet_05v0 ad=0.26p pd=1.52u as=0.26p ps=1.52u w=1u l=0.5u
X3 a_n256_n76# a_n356_n168# a_n444_n76# w_n530_n254# pfet_05v0 ad=0.26p pd=1.52u as=0.44p ps=2.88u w=1u l=0.5u
.ends

.subckt pfet_06v0_27GLKX a_n5876_n1000# a_5324_n1000# a_1516_n1000# a_1172_n1092#
+ a_6772_n1092# a_n2188_n1092# a_n2860_n1092# a_n7788_n1092# a_n1396_n1000# a_2964_n1092#
+ a_n6996_n1000# a_n724_n1000# a_6444_n1000# a_2636_n1000# a_2292_n1092# a_7892_n1092#
+ a_n3980_n1092# a_n8116_n1000# a_7564_n1000# a_n4308_n1000# a_3756_n1000# a_52_n1092#
+ a_9012_n1092# w_n9978_n1178# a_n5100_n1092# a_5204_n1092# a_n9236_n1000# a_3084_n1000#
+ a_8684_n1000# a_n5428_n1000# a_4876_n1000# a_n6220_n1092# a_n9892_n1000# a_6324_n1092#
+ a_n2412_n1092# a_2516_n1092# a_n6548_n1000# a_n1620_n1000# a_844_n1000# a_5996_n1000#
+ a_n396_n1092# a_n7340_n1092# a_172_n1000# a_7444_n1092# a_n2068_n1000# a_3636_n1092#
+ a_n3532_n1092# a_n7668_n1000# a_n2740_n1000# a_7116_n1000# a_3308_n1000# a_8908_n1000#
+ a_n8460_n1092# a_8564_n1092# a_n3188_n1000# a_4756_n1092# a_n4652_n1092# a_n8788_n1000#
+ a_n3860_n1000# a_8236_n1000# a_4428_n1000# a_4084_n1092# a_9684_n1092# a_n9580_n1092#
+ a_724_n1092# a_5876_n1092# a_n5772_n1092# a_n4980_n1000# a_n1964_n1092# a_9356_n1000#
+ a_5548_n1000# a_n1292_n1092# a_1396_n1092# a_n620_n1092# a_n6892_n1092# a_n6100_n1000#
+ a_6996_n1092# a_1068_n1000# a_n948_n1000# a_1740_n1000# a_6668_n1000# a_n8012_n1092#
+ a_n276_n1000# a_8116_n1092# a_n7220_n1000# a_n4204_n1092# a_4308_n1092# a_n9804_n1092#
+ a_n3412_n1000# a_2188_n1000# a_2860_n1000# a_7788_n1000# a_n9132_n1092# a_9236_n1092#
+ a_n8340_n1000# a_n5324_n1092# a_5428_n1092# a_n4532_n1000# a_n1516_n1092# a_3980_n1000#
+ a_n9460_n1000# a_n6444_n1092# a_6548_n1092# a_1620_n1092# a_n5652_n1000# a_5100_n1000#
+ a_n2636_n1092# a_n1844_n1000# a_2068_n1092# a_n1172_n1000# a_7668_n1092# a_2740_n1092#
+ a_n7564_n1092# a_n500_n1000# a_396_n1000# a_n3756_n1092# a_n6772_n1000# a_6220_n1000#
+ a_n2964_n1000# a_2412_n1000# a_n3084_n1092# a_3188_n1092# a_8788_n1092# a_n2292_n1000#
+ a_3860_n1092# a_n8684_n1092# a_n4876_n1092# a_n7892_n1000# a_7340_n1000# a_3532_n1000#
+ a_n9012_n1000# a_4980_n1092# a_948_n1092# a_n5996_n1092# a_n5204_n1000# a_8460_n1000#
+ a_4652_n1000# a_276_n1092# a_6100_n1092# a_n7116_n1092# a_n844_n1092# a_n6324_n1000#
+ a_620_n1000# a_9580_n1000# a_n3308_n1092# a_5772_n1000# a_n8908_n1092# a_n2516_n1000#
+ a_n172_n1092# a_1964_n1000# a_7220_n1092# a_n8236_n1092# a_3412_n1092# a_n7444_n1000#
+ a_1292_n1000# a_n4428_n1092# a_6892_n1000# a_n3636_n1000# a_8340_n1092# a_n9356_n1092#
+ a_4532_n1092# a_n8564_n1000# a_8012_n1000# a_n5548_n1092# a_n4756_n1000# a_4204_n1000#
+ a_9804_n1000# a_9460_n1092# a_500_n1092# a_n4084_n1000# a_n1068_n1092# a_5652_n1092#
+ a_n9684_n1000# a_n52_n1000# a_9132_n1000# a_1844_n1092# a_n1740_n1092# a_n6668_n1092#
X0 a_n8788_n1000# a_n8908_n1092# a_n9012_n1000# w_n9978_n1178# pfet_06v0 ad=2.6p pd=10.52u as=2.6p ps=10.52u w=10u l=0.6u
X1 a_n4308_n1000# a_n4428_n1092# a_n4532_n1000# w_n9978_n1178# pfet_06v0 ad=2.6p pd=10.52u as=2.6p ps=10.52u w=10u l=0.6u
X2 a_n2292_n1000# a_n2412_n1092# a_n2516_n1000# w_n9978_n1178# pfet_06v0 ad=2.6p pd=10.52u as=2.6p ps=10.52u w=10u l=0.6u
X3 a_7340_n1000# a_7220_n1092# a_7116_n1000# w_n9978_n1178# pfet_06v0 ad=2.6p pd=10.52u as=2.6p ps=10.52u w=10u l=0.6u
X4 a_9356_n1000# a_9236_n1092# a_9132_n1000# w_n9978_n1178# pfet_06v0 ad=2.6p pd=10.52u as=2.6p ps=10.52u w=10u l=0.6u
X5 a_n4756_n1000# a_n4876_n1092# a_n4980_n1000# w_n9978_n1178# pfet_06v0 ad=2.6p pd=10.52u as=2.6p ps=10.52u w=10u l=0.6u
X6 a_n948_n1000# a_n1068_n1092# a_n1172_n1000# w_n9978_n1178# pfet_06v0 ad=2.6p pd=10.52u as=2.6p ps=10.52u w=10u l=0.6u
X7 a_9804_n1000# a_9684_n1092# a_9580_n1000# w_n9978_n1178# pfet_06v0 ad=4.4p pd=20.88u as=2.6p ps=10.52u w=10u l=0.6u
X8 a_n5428_n1000# a_n5548_n1092# a_n5652_n1000# w_n9978_n1178# pfet_06v0 ad=2.6p pd=10.52u as=2.6p ps=10.52u w=10u l=0.6u
X9 a_n3412_n1000# a_n3532_n1092# a_n3636_n1000# w_n9978_n1178# pfet_06v0 ad=2.6p pd=10.52u as=2.6p ps=10.52u w=10u l=0.6u
X10 a_8460_n1000# a_8340_n1092# a_8236_n1000# w_n9978_n1178# pfet_06v0 ad=2.6p pd=10.52u as=2.6p ps=10.52u w=10u l=0.6u
X11 a_n6100_n1000# a_n6220_n1092# a_n6324_n1000# w_n9978_n1178# pfet_06v0 ad=2.6p pd=10.52u as=2.6p ps=10.52u w=10u l=0.6u
X12 a_n5876_n1000# a_n5996_n1092# a_n6100_n1000# w_n9978_n1178# pfet_06v0 ad=2.6p pd=10.52u as=2.6p ps=10.52u w=10u l=0.6u
X13 a_n4084_n1000# a_n4204_n1092# a_n4308_n1000# w_n9978_n1178# pfet_06v0 ad=2.6p pd=10.52u as=2.6p ps=10.52u w=10u l=0.6u
X14 a_n2068_n1000# a_n2188_n1092# a_n2292_n1000# w_n9978_n1178# pfet_06v0 ad=2.6p pd=10.52u as=2.6p ps=10.52u w=10u l=0.6u
X15 a_n724_n1000# a_n844_n1092# a_n948_n1000# w_n9978_n1178# pfet_06v0 ad=2.6p pd=10.52u as=2.6p ps=10.52u w=10u l=0.6u
X16 a_9132_n1000# a_9012_n1092# a_8908_n1000# w_n9978_n1178# pfet_06v0 ad=2.6p pd=10.52u as=2.6p ps=10.52u w=10u l=0.6u
X17 a_n6548_n1000# a_n6668_n1092# a_n6772_n1000# w_n9978_n1178# pfet_06v0 ad=2.6p pd=10.52u as=2.6p ps=10.52u w=10u l=0.6u
X18 a_9580_n1000# a_9460_n1092# a_9356_n1000# w_n9978_n1178# pfet_06v0 ad=2.6p pd=10.52u as=2.6p ps=10.52u w=10u l=0.6u
X19 a_n7220_n1000# a_n7340_n1092# a_n7444_n1000# w_n9978_n1178# pfet_06v0 ad=2.6p pd=10.52u as=2.6p ps=10.52u w=10u l=0.6u
X20 a_n5204_n1000# a_n5324_n1092# a_n5428_n1000# w_n9978_n1178# pfet_06v0 ad=2.6p pd=10.52u as=2.6p ps=10.52u w=10u l=0.6u
X21 a_n4532_n1000# a_n4652_n1092# a_n4756_n1000# w_n9978_n1178# pfet_06v0 ad=2.6p pd=10.52u as=2.6p ps=10.52u w=10u l=0.6u
X22 a_n9684_n1000# a_n9804_n1092# a_n9892_n1000# w_n9978_n1178# pfet_06v0 ad=2.6p pd=10.52u as=4.4p ps=20.88u w=10u l=0.6u
X23 a_n7668_n1000# a_n7788_n1092# a_n7892_n1000# w_n9978_n1178# pfet_06v0 ad=2.6p pd=10.52u as=2.6p ps=10.52u w=10u l=0.6u
X24 a_n1172_n1000# a_n1292_n1092# a_n1396_n1000# w_n9978_n1178# pfet_06v0 ad=2.6p pd=10.52u as=2.6p ps=10.52u w=10u l=0.6u
X25 a_n8340_n1000# a_n8460_n1092# a_n8564_n1000# w_n9978_n1178# pfet_06v0 ad=2.6p pd=10.52u as=2.6p ps=10.52u w=10u l=0.6u
X26 a_n5652_n1000# a_n5772_n1092# a_n5876_n1000# w_n9978_n1178# pfet_06v0 ad=2.6p pd=10.52u as=2.6p ps=10.52u w=10u l=0.6u
X27 a_n6996_n1000# a_n7116_n1092# a_n7220_n1000# w_n9978_n1178# pfet_06v0 ad=2.6p pd=10.52u as=2.6p ps=10.52u w=10u l=0.6u
X28 a_n6324_n1000# a_n6444_n1092# a_n6548_n1000# w_n9978_n1178# pfet_06v0 ad=2.6p pd=10.52u as=2.6p ps=10.52u w=10u l=0.6u
X29 a_n9460_n1000# a_n9580_n1092# a_n9684_n1000# w_n9978_n1178# pfet_06v0 ad=2.6p pd=10.52u as=2.6p ps=10.52u w=10u l=0.6u
X30 a_n6772_n1000# a_n6892_n1092# a_n6996_n1000# w_n9978_n1178# pfet_06v0 ad=2.6p pd=10.52u as=2.6p ps=10.52u w=10u l=0.6u
X31 a_n4980_n1000# a_n5100_n1092# a_n5204_n1000# w_n9978_n1178# pfet_06v0 ad=2.6p pd=10.52u as=2.6p ps=10.52u w=10u l=0.6u
X32 a_n2964_n1000# a_n3084_n1092# a_n3188_n1000# w_n9978_n1178# pfet_06v0 ad=2.6p pd=10.52u as=2.6p ps=10.52u w=10u l=0.6u
X33 a_n8116_n1000# a_n8236_n1092# a_n8340_n1000# w_n9978_n1178# pfet_06v0 ad=2.6p pd=10.52u as=2.6p ps=10.52u w=10u l=0.6u
X34 a_n7444_n1000# a_n7564_n1092# a_n7668_n1000# w_n9978_n1178# pfet_06v0 ad=2.6p pd=10.52u as=2.6p ps=10.52u w=10u l=0.6u
X35 a_n276_n1000# a_n396_n1092# a_n500_n1000# w_n9978_n1178# pfet_06v0 ad=2.6p pd=10.52u as=2.6p ps=10.52u w=10u l=0.6u
X36 a_n8564_n1000# a_n8684_n1092# a_n8788_n1000# w_n9978_n1178# pfet_06v0 ad=2.6p pd=10.52u as=2.6p ps=10.52u w=10u l=0.6u
X37 a_n9236_n1000# a_n9356_n1092# a_n9460_n1000# w_n9978_n1178# pfet_06v0 ad=2.6p pd=10.52u as=2.6p ps=10.52u w=10u l=0.6u
X38 a_n52_n1000# a_n172_n1092# a_n276_n1000# w_n9978_n1178# pfet_06v0 ad=2.6p pd=10.52u as=2.6p ps=10.52u w=10u l=0.6u
X39 a_n7892_n1000# a_n8012_n1092# a_n8116_n1000# w_n9978_n1178# pfet_06v0 ad=2.6p pd=10.52u as=2.6p ps=10.52u w=10u l=0.6u
X40 a_1964_n1000# a_1844_n1092# a_1740_n1000# w_n9978_n1178# pfet_06v0 ad=2.6p pd=10.52u as=2.6p ps=10.52u w=10u l=0.6u
X41 a_n9012_n1000# a_n9132_n1092# a_n9236_n1000# w_n9978_n1178# pfet_06v0 ad=2.6p pd=10.52u as=2.6p ps=10.52u w=10u l=0.6u
X42 a_2636_n1000# a_2516_n1092# a_2412_n1000# w_n9978_n1178# pfet_06v0 ad=2.6p pd=10.52u as=2.6p ps=10.52u w=10u l=0.6u
X43 a_3084_n1000# a_2964_n1092# a_2860_n1000# w_n9978_n1178# pfet_06v0 ad=2.6p pd=10.52u as=2.6p ps=10.52u w=10u l=0.6u
X44 a_3756_n1000# a_3636_n1092# a_3532_n1000# w_n9978_n1178# pfet_06v0 ad=2.6p pd=10.52u as=2.6p ps=10.52u w=10u l=0.6u
X45 a_1740_n1000# a_1620_n1092# a_1516_n1000# w_n9978_n1178# pfet_06v0 ad=2.6p pd=10.52u as=2.6p ps=10.52u w=10u l=0.6u
X46 a_4428_n1000# a_4308_n1092# a_4204_n1000# w_n9978_n1178# pfet_06v0 ad=2.6p pd=10.52u as=2.6p ps=10.52u w=10u l=0.6u
X47 a_4876_n1000# a_4756_n1092# a_4652_n1000# w_n9978_n1178# pfet_06v0 ad=2.6p pd=10.52u as=2.6p ps=10.52u w=10u l=0.6u
X48 a_1068_n1000# a_948_n1092# a_844_n1000# w_n9978_n1178# pfet_06v0 ad=2.6p pd=10.52u as=2.6p ps=10.52u w=10u l=0.6u
X49 a_2860_n1000# a_2740_n1092# a_2636_n1000# w_n9978_n1178# pfet_06v0 ad=2.6p pd=10.52u as=2.6p ps=10.52u w=10u l=0.6u
X50 a_3532_n1000# a_3412_n1092# a_3308_n1000# w_n9978_n1178# pfet_06v0 ad=2.6p pd=10.52u as=2.6p ps=10.52u w=10u l=0.6u
X51 a_5548_n1000# a_5428_n1092# a_5324_n1000# w_n9978_n1178# pfet_06v0 ad=2.6p pd=10.52u as=2.6p ps=10.52u w=10u l=0.6u
X52 a_1516_n1000# a_1396_n1092# a_1292_n1000# w_n9978_n1178# pfet_06v0 ad=2.6p pd=10.52u as=2.6p ps=10.52u w=10u l=0.6u
X53 a_2188_n1000# a_2068_n1092# a_1964_n1000# w_n9978_n1178# pfet_06v0 ad=2.6p pd=10.52u as=2.6p ps=10.52u w=10u l=0.6u
X54 a_5996_n1000# a_5876_n1092# a_5772_n1000# w_n9978_n1178# pfet_06v0 ad=2.6p pd=10.52u as=2.6p ps=10.52u w=10u l=0.6u
X55 a_n1620_n1000# a_n1740_n1092# a_n1844_n1000# w_n9978_n1178# pfet_06v0 ad=2.6p pd=10.52u as=2.6p ps=10.52u w=10u l=0.6u
X56 a_3980_n1000# a_3860_n1092# a_3756_n1000# w_n9978_n1178# pfet_06v0 ad=2.6p pd=10.52u as=2.6p ps=10.52u w=10u l=0.6u
X57 a_6668_n1000# a_6548_n1092# a_6444_n1000# w_n9978_n1178# pfet_06v0 ad=2.6p pd=10.52u as=2.6p ps=10.52u w=10u l=0.6u
X58 a_172_n1000# a_52_n1092# a_n52_n1000# w_n9978_n1178# pfet_06v0 ad=2.6p pd=10.52u as=2.6p ps=10.52u w=10u l=0.6u
X59 a_4652_n1000# a_4532_n1092# a_4428_n1000# w_n9978_n1178# pfet_06v0 ad=2.6p pd=10.52u as=2.6p ps=10.52u w=10u l=0.6u
X60 a_5324_n1000# a_5204_n1092# a_5100_n1000# w_n9978_n1178# pfet_06v0 ad=2.6p pd=10.52u as=2.6p ps=10.52u w=10u l=0.6u
X61 a_7116_n1000# a_6996_n1092# a_6892_n1000# w_n9978_n1178# pfet_06v0 ad=2.6p pd=10.52u as=2.6p ps=10.52u w=10u l=0.6u
X62 a_n2740_n1000# a_n2860_n1092# a_n2964_n1000# w_n9978_n1178# pfet_06v0 ad=2.6p pd=10.52u as=2.6p ps=10.52u w=10u l=0.6u
X63 a_844_n1000# a_724_n1092# a_620_n1000# w_n9978_n1178# pfet_06v0 ad=2.6p pd=10.52u as=2.6p ps=10.52u w=10u l=0.6u
X64 a_1292_n1000# a_1172_n1092# a_1068_n1000# w_n9978_n1178# pfet_06v0 ad=2.6p pd=10.52u as=2.6p ps=10.52u w=10u l=0.6u
X65 a_3308_n1000# a_3188_n1092# a_3084_n1000# w_n9978_n1178# pfet_06v0 ad=2.6p pd=10.52u as=2.6p ps=10.52u w=10u l=0.6u
X66 a_5100_n1000# a_4980_n1092# a_4876_n1000# w_n9978_n1178# pfet_06v0 ad=2.6p pd=10.52u as=2.6p ps=10.52u w=10u l=0.6u
X67 a_7788_n1000# a_7668_n1092# a_7564_n1000# w_n9978_n1178# pfet_06v0 ad=2.6p pd=10.52u as=2.6p ps=10.52u w=10u l=0.6u
X68 a_5772_n1000# a_5652_n1092# a_5548_n1000# w_n9978_n1178# pfet_06v0 ad=2.6p pd=10.52u as=2.6p ps=10.52u w=10u l=0.6u
X69 a_n1396_n1000# a_n1516_n1092# a_n1620_n1000# w_n9978_n1178# pfet_06v0 ad=2.6p pd=10.52u as=2.6p ps=10.52u w=10u l=0.6u
X70 a_2412_n1000# a_2292_n1092# a_2188_n1000# w_n9978_n1178# pfet_06v0 ad=2.6p pd=10.52u as=2.6p ps=10.52u w=10u l=0.6u
X71 a_6444_n1000# a_6324_n1092# a_6220_n1000# w_n9978_n1178# pfet_06v0 ad=2.6p pd=10.52u as=2.6p ps=10.52u w=10u l=0.6u
X72 a_8908_n1000# a_8788_n1092# a_8684_n1000# w_n9978_n1178# pfet_06v0 ad=2.6p pd=10.52u as=2.6p ps=10.52u w=10u l=0.6u
X73 a_n3860_n1000# a_n3980_n1092# a_n4084_n1000# w_n9978_n1178# pfet_06v0 ad=2.6p pd=10.52u as=2.6p ps=10.52u w=10u l=0.6u
X74 a_n1844_n1000# a_n1964_n1092# a_n2068_n1000# w_n9978_n1178# pfet_06v0 ad=2.6p pd=10.52u as=2.6p ps=10.52u w=10u l=0.6u
X75 a_620_n1000# a_500_n1092# a_396_n1000# w_n9978_n1178# pfet_06v0 ad=2.6p pd=10.52u as=2.6p ps=10.52u w=10u l=0.6u
X76 a_6892_n1000# a_6772_n1092# a_6668_n1000# w_n9978_n1178# pfet_06v0 ad=2.6p pd=10.52u as=2.6p ps=10.52u w=10u l=0.6u
X77 a_n2516_n1000# a_n2636_n1092# a_n2740_n1000# w_n9978_n1178# pfet_06v0 ad=2.6p pd=10.52u as=2.6p ps=10.52u w=10u l=0.6u
X78 a_7564_n1000# a_7444_n1092# a_7340_n1000# w_n9978_n1178# pfet_06v0 ad=2.6p pd=10.52u as=2.6p ps=10.52u w=10u l=0.6u
X79 a_8236_n1000# a_8116_n1092# a_8012_n1000# w_n9978_n1178# pfet_06v0 ad=2.6p pd=10.52u as=2.6p ps=10.52u w=10u l=0.6u
X80 a_n3188_n1000# a_n3308_n1092# a_n3412_n1000# w_n9978_n1178# pfet_06v0 ad=2.6p pd=10.52u as=2.6p ps=10.52u w=10u l=0.6u
X81 a_n500_n1000# a_n620_n1092# a_n724_n1000# w_n9978_n1178# pfet_06v0 ad=2.6p pd=10.52u as=2.6p ps=10.52u w=10u l=0.6u
X82 a_4204_n1000# a_4084_n1092# a_3980_n1000# w_n9978_n1178# pfet_06v0 ad=2.6p pd=10.52u as=2.6p ps=10.52u w=10u l=0.6u
X83 a_6220_n1000# a_6100_n1092# a_5996_n1000# w_n9978_n1178# pfet_06v0 ad=2.6p pd=10.52u as=2.6p ps=10.52u w=10u l=0.6u
X84 a_8012_n1000# a_7892_n1092# a_7788_n1000# w_n9978_n1178# pfet_06v0 ad=2.6p pd=10.52u as=2.6p ps=10.52u w=10u l=0.6u
X85 a_n3636_n1000# a_n3756_n1092# a_n3860_n1000# w_n9978_n1178# pfet_06v0 ad=2.6p pd=10.52u as=2.6p ps=10.52u w=10u l=0.6u
X86 a_396_n1000# a_276_n1092# a_172_n1000# w_n9978_n1178# pfet_06v0 ad=2.6p pd=10.52u as=2.6p ps=10.52u w=10u l=0.6u
X87 a_8684_n1000# a_8564_n1092# a_8460_n1000# w_n9978_n1178# pfet_06v0 ad=2.6p pd=10.52u as=2.6p ps=10.52u w=10u l=0.6u
.ends

.subckt gate_drive_large in_p in_n out outn vss vdd
Xnfet_05v0_BJME2D_0 vss outn outn vss vss outn outn m3_310_506# out vss vss outn outn
+ m3_310_506# vss outn out outn outn outn outn m3_310_506# vss outn vss outn out m3_310_506#
+ out outn outn m3_310_506# m3_n171_480# outn out vss outn outn outn outn vss outn
+ m3_310_506# vss outn outn m3_310_506# out out out outn m3_310_506# vss vss outn
+ m3_n171_480# m3_310_506# vss vss outn outn outn vss out out m3_310_506# m3_n876_2034#
+ vss vss out outn outn outn m3_n171_480# outn vss vss outn outn outn outn vss vss
+ m3_n171_480# outn out outn outn outn vss vss outn vss outn out outn outn vss vss
+ vss outn m3_310_506# outn out vss m3_310_506# outn m3_310_506# vss m3_n171_480#
+ vss vss outn outn outn out vss vss outn m3_310_506# out vss out outn m3_n876_2034#
+ vss out outn m3_310_506# outn m3_310_506# out out outn outn outn m3_310_506# vss
+ out vss out outn outn out m3_n171_480# m3_n171_480# outn out outn outn m3_310_506#
+ out out vss outn outn outn out m3_310_506# vss vss outn out m3_310_506# outn outn
+ outn m3_310_506# vss vss vss outn m3_310_506# m3_310_506# out vss vss out nfet_05v0_BJME2D
Xnfet_05v0_AGRLGL_0 vss m3_n876_2034# in_p in_n m3_n1229_754# vss in_n vss in_p vss
+ nfet_05v0_AGRLGL
Xpfet_05v0_X3LYAZ_0 m3_n1229_754# vdd vdd m3_n1229_754# m3_n876_2034# m3_n876_2034#
+ vdd vdd m3_n1229_754# m3_n876_2034# pfet_05v0_X3LYAZ
Xpfet_06v0_27GLKX_0 vdd vdd out outn outn outn outn m3_310_506# vdd outn outn out
+ out vdd outn outn m3_310_506# vdd vdd outn out outn outn vdd m3_310_506# outn m3_310_506#
+ vdd out vdd vdd m3_310_506# vdd outn outn outn outn out vdd out outn m3_310_506#
+ out outn out outn outn vdd vdd vdd out vdd m3_n171_480# outn vdd outn m3_310_506#
+ m3_310_506# outn out vdd outn outn m3_n876_2034# outn outn m3_310_506# vdd outn
+ vdd out outn outn outn m3_310_506# outn outn out vdd vdd vdd m3_310_506# out outn
+ vdd m3_310_506# outn m3_n876_2034# out vdd out out m3_n171_480# outn m3_310_506#
+ m3_310_506# outn vdd outn vdd vdd m3_310_506# outn outn outn out outn vdd outn out
+ outn outn m3_310_506# vdd vdd m3_310_506# vdd vdd out out outn outn outn vdd outn
+ m3_n171_480# m3_310_506# outn out vdd vdd outn outn m3_310_506# outn vdd out outn
+ outn m3_310_506# outn vdd out out outn vdd m3_n171_480# out outn out outn m3_n171_480#
+ outn outn vdd m3_310_506# out vdd outn m3_n171_480# outn vdd vdd m3_310_506# outn
+ out vdd outn outn vdd outn outn m3_n171_480# vdd out outn outn m3_310_506# pfet_06v0_27GLKX
.ends

.subckt power_stage IOVDD_IN IOVDD_OUT DVDD DVSS IOVSS enable
Xpfet_05v0_WX3F8K_0[0] gate_drive_large_0/out IOVDD_IN IOVDD_OUT gate_drive_large_0/out
+ IOVDD_OUT gate_drive_large_0/out IOVDD_OUT gate_drive_large_0/out IOVDD_OUT gate_drive_large_0/out
+ IOVDD_IN gate_drive_large_0/out IOVDD_IN gate_drive_large_0/out gate_drive_large_0/out
+ gate_drive_large_0/out IOVDD_IN gate_drive_large_0/out IOVDD_IN gate_drive_large_0/out
+ IOVDD_IN gate_drive_large_0/out IOVDD_OUT gate_drive_large_0/out gate_drive_large_0/out
+ IOVDD_OUT gate_drive_large_0/out IOVDD_OUT gate_drive_large_0/out gate_drive_large_0/out
+ gate_drive_large_0/out IOVDD_IN IOVDD_IN gate_drive_large_0/out gate_drive_large_0/out
+ IOVDD_IN IOVDD_IN gate_drive_large_0/out IOVDD_OUT gate_drive_large_0/out gate_drive_large_0/out
+ IOVDD_OUT gate_drive_large_0/out IOVDD_OUT gate_drive_large_0/out IOVDD_OUT gate_drive_large_0/out
+ gate_drive_large_0/out gate_drive_large_0/out gate_drive_large_0/out gate_drive_large_0/out
+ IOVDD_OUT IOVDD_IN gate_drive_large_0/out IOVDD_IN IOVDD_IN IOVDD_OUT IOVDD_OUT
+ IOVDD_IN gate_drive_large_0/out gate_drive_large_0/out IOVDD_IN IOVDD_IN gate_drive_large_0/out
+ gate_drive_large_0/out IOVDD_IN gate_drive_large_0/out IOVDD_OUT gate_drive_large_0/out
+ IOVDD_IN gate_drive_large_0/out IOVDD_IN gate_drive_large_0/out IOVDD_OUT gate_drive_large_0/out
+ IOVDD_IN gate_drive_large_0/out IOVDD_OUT IOVDD_OUT IOVDD_OUT gate_drive_large_0/out
+ IOVDD_OUT IOVDD_OUT gate_drive_large_0/out IOVDD_OUT IOVDD_IN gate_drive_large_0/out
+ IOVDD_IN gate_drive_large_0/out IOVDD_OUT IOVDD_OUT gate_drive_large_0/out gate_drive_large_0/out
+ gate_drive_large_0/out IOVDD_OUT IOVDD_OUT gate_drive_large_0/out IOVDD_OUT gate_drive_large_0/out
+ IOVDD_OUT IOVDD_IN gate_drive_large_0/out gate_drive_large_0/out IOVDD_IN IOVDD_IN
+ gate_drive_large_0/out IOVDD_OUT gate_drive_large_0/out IOVDD_OUT gate_drive_large_0/out
+ IOVDD_OUT IOVDD_OUT gate_drive_large_0/out gate_drive_large_0/out IOVDD_OUT IOVDD_IN
+ gate_drive_large_0/out IOVDD_OUT IOVDD_IN IOVDD_OUT gate_drive_large_0/out IOVDD_IN
+ IOVDD_IN IOVDD_OUT IOVDD_OUT gate_drive_large_0/out gate_drive_large_0/out IOVDD_OUT
+ IOVDD_IN IOVDD_IN IOVDD_IN gate_drive_large_0/out gate_drive_large_0/out gate_drive_large_0/out
+ gate_drive_large_0/out IOVDD_IN IOVDD_OUT gate_drive_large_0/out IOVDD_IN IOVDD_OUT
+ gate_drive_large_0/out gate_drive_large_0/out IOVDD_OUT IOVDD_IN gate_drive_large_0/out
+ IOVDD_OUT IOVDD_OUT IOVDD_OUT gate_drive_large_0/out gate_drive_large_0/out gate_drive_large_0/out
+ IOVDD_IN IOVDD_OUT gate_drive_large_0/out IOVDD_OUT gate_drive_large_0/out IOVDD_OUT
+ gate_drive_large_0/out gate_drive_large_0/out gate_drive_large_0/out IOVDD_IN gate_drive_large_0/out
+ IOVDD_IN gate_drive_large_0/out IOVDD_OUT IOVDD_OUT gate_drive_large_0/out IOVDD_IN
+ IOVDD_OUT gate_drive_large_0/out IOVDD_IN IOVDD_IN IOVDD_IN IOVDD_IN IOVDD_IN gate_drive_large_0/out
+ gate_drive_large_0/out gate_drive_large_0/out gate_drive_large_0/out IOVDD_OUT gate_drive_large_0/out
+ IOVDD_OUT gate_drive_large_0/out gate_drive_large_0/out IOVDD_IN gate_drive_large_0/out
+ IOVDD_IN IOVDD_OUT IOVDD_OUT gate_drive_large_0/out pfet_05v0_WX3F8K
Xpfet_05v0_WX3F8K_0[1] gate_drive_large_0/out IOVDD_IN IOVDD_OUT gate_drive_large_0/out
+ IOVDD_OUT gate_drive_large_0/out IOVDD_OUT gate_drive_large_0/out IOVDD_OUT gate_drive_large_0/out
+ IOVDD_IN gate_drive_large_0/out IOVDD_IN gate_drive_large_0/out gate_drive_large_0/out
+ gate_drive_large_0/out IOVDD_IN gate_drive_large_0/out IOVDD_IN gate_drive_large_0/out
+ IOVDD_IN gate_drive_large_0/out IOVDD_OUT gate_drive_large_0/out gate_drive_large_0/out
+ IOVDD_OUT gate_drive_large_0/out IOVDD_OUT gate_drive_large_0/out gate_drive_large_0/out
+ gate_drive_large_0/out IOVDD_IN IOVDD_IN gate_drive_large_0/out gate_drive_large_0/out
+ IOVDD_IN IOVDD_IN gate_drive_large_0/out IOVDD_OUT gate_drive_large_0/out gate_drive_large_0/out
+ IOVDD_OUT gate_drive_large_0/out IOVDD_OUT gate_drive_large_0/out IOVDD_OUT gate_drive_large_0/out
+ gate_drive_large_0/out gate_drive_large_0/out gate_drive_large_0/out gate_drive_large_0/out
+ IOVDD_OUT IOVDD_IN gate_drive_large_0/out IOVDD_IN IOVDD_IN IOVDD_OUT IOVDD_OUT
+ IOVDD_IN gate_drive_large_0/out gate_drive_large_0/out IOVDD_IN IOVDD_IN gate_drive_large_0/out
+ gate_drive_large_0/out IOVDD_IN gate_drive_large_0/out IOVDD_OUT gate_drive_large_0/out
+ IOVDD_IN gate_drive_large_0/out IOVDD_IN gate_drive_large_0/out IOVDD_OUT gate_drive_large_0/out
+ IOVDD_IN gate_drive_large_0/out IOVDD_OUT IOVDD_OUT IOVDD_OUT gate_drive_large_0/out
+ IOVDD_OUT IOVDD_OUT gate_drive_large_0/out IOVDD_OUT IOVDD_IN gate_drive_large_0/out
+ IOVDD_IN gate_drive_large_0/out IOVDD_OUT IOVDD_OUT gate_drive_large_0/out gate_drive_large_0/out
+ gate_drive_large_0/out IOVDD_OUT IOVDD_OUT gate_drive_large_0/out IOVDD_OUT gate_drive_large_0/out
+ IOVDD_OUT IOVDD_IN gate_drive_large_0/out gate_drive_large_0/out IOVDD_IN IOVDD_IN
+ gate_drive_large_0/out IOVDD_OUT gate_drive_large_0/out IOVDD_OUT gate_drive_large_0/out
+ IOVDD_OUT IOVDD_OUT gate_drive_large_0/out gate_drive_large_0/out IOVDD_OUT IOVDD_IN
+ gate_drive_large_0/out IOVDD_OUT IOVDD_IN IOVDD_OUT gate_drive_large_0/out IOVDD_IN
+ IOVDD_IN IOVDD_OUT IOVDD_OUT gate_drive_large_0/out gate_drive_large_0/out IOVDD_OUT
+ IOVDD_IN IOVDD_IN IOVDD_IN gate_drive_large_0/out gate_drive_large_0/out gate_drive_large_0/out
+ gate_drive_large_0/out IOVDD_IN IOVDD_OUT gate_drive_large_0/out IOVDD_IN IOVDD_OUT
+ gate_drive_large_0/out gate_drive_large_0/out IOVDD_OUT IOVDD_IN gate_drive_large_0/out
+ IOVDD_OUT IOVDD_OUT IOVDD_OUT gate_drive_large_0/out gate_drive_large_0/out gate_drive_large_0/out
+ IOVDD_IN IOVDD_OUT gate_drive_large_0/out IOVDD_OUT gate_drive_large_0/out IOVDD_OUT
+ gate_drive_large_0/out gate_drive_large_0/out gate_drive_large_0/out IOVDD_IN gate_drive_large_0/out
+ IOVDD_IN gate_drive_large_0/out IOVDD_OUT IOVDD_OUT gate_drive_large_0/out IOVDD_IN
+ IOVDD_OUT gate_drive_large_0/out IOVDD_IN IOVDD_IN IOVDD_IN IOVDD_IN IOVDD_IN gate_drive_large_0/out
+ gate_drive_large_0/out gate_drive_large_0/out gate_drive_large_0/out IOVDD_OUT gate_drive_large_0/out
+ IOVDD_OUT gate_drive_large_0/out gate_drive_large_0/out IOVDD_IN gate_drive_large_0/out
+ IOVDD_IN IOVDD_OUT IOVDD_OUT gate_drive_large_0/out pfet_05v0_WX3F8K
Xpfet_05v0_WX3F8K_0[2] gate_drive_large_0/out IOVDD_IN IOVDD_OUT gate_drive_large_0/out
+ IOVDD_OUT gate_drive_large_0/out IOVDD_OUT gate_drive_large_0/out IOVDD_OUT gate_drive_large_0/out
+ IOVDD_IN gate_drive_large_0/out IOVDD_IN gate_drive_large_0/out gate_drive_large_0/out
+ gate_drive_large_0/out IOVDD_IN gate_drive_large_0/out IOVDD_IN gate_drive_large_0/out
+ IOVDD_IN gate_drive_large_0/out IOVDD_OUT gate_drive_large_0/out gate_drive_large_0/out
+ IOVDD_OUT gate_drive_large_0/out IOVDD_OUT gate_drive_large_0/out gate_drive_large_0/out
+ gate_drive_large_0/out IOVDD_IN IOVDD_IN gate_drive_large_0/out gate_drive_large_0/out
+ IOVDD_IN IOVDD_IN gate_drive_large_0/out IOVDD_OUT gate_drive_large_0/out gate_drive_large_0/out
+ IOVDD_OUT gate_drive_large_0/out IOVDD_OUT gate_drive_large_0/out IOVDD_OUT gate_drive_large_0/out
+ gate_drive_large_0/out gate_drive_large_0/out gate_drive_large_0/out gate_drive_large_0/out
+ IOVDD_OUT IOVDD_IN gate_drive_large_0/out IOVDD_IN IOVDD_IN IOVDD_OUT IOVDD_OUT
+ IOVDD_IN gate_drive_large_0/out gate_drive_large_0/out IOVDD_IN IOVDD_IN gate_drive_large_0/out
+ gate_drive_large_0/out IOVDD_IN gate_drive_large_0/out IOVDD_OUT gate_drive_large_0/out
+ IOVDD_IN gate_drive_large_0/out IOVDD_IN gate_drive_large_0/out IOVDD_OUT gate_drive_large_0/out
+ IOVDD_IN gate_drive_large_0/out IOVDD_OUT IOVDD_OUT IOVDD_OUT gate_drive_large_0/out
+ IOVDD_OUT IOVDD_OUT gate_drive_large_0/out IOVDD_OUT IOVDD_IN gate_drive_large_0/out
+ IOVDD_IN gate_drive_large_0/out IOVDD_OUT IOVDD_OUT gate_drive_large_0/out gate_drive_large_0/out
+ gate_drive_large_0/out IOVDD_OUT IOVDD_OUT gate_drive_large_0/out IOVDD_OUT gate_drive_large_0/out
+ IOVDD_OUT IOVDD_IN gate_drive_large_0/out gate_drive_large_0/out IOVDD_IN IOVDD_IN
+ gate_drive_large_0/out IOVDD_OUT gate_drive_large_0/out IOVDD_OUT gate_drive_large_0/out
+ IOVDD_OUT IOVDD_OUT gate_drive_large_0/out gate_drive_large_0/out IOVDD_OUT IOVDD_IN
+ gate_drive_large_0/out IOVDD_OUT IOVDD_IN IOVDD_OUT gate_drive_large_0/out IOVDD_IN
+ IOVDD_IN IOVDD_OUT IOVDD_OUT gate_drive_large_0/out gate_drive_large_0/out IOVDD_OUT
+ IOVDD_IN IOVDD_IN IOVDD_IN gate_drive_large_0/out gate_drive_large_0/out gate_drive_large_0/out
+ gate_drive_large_0/out IOVDD_IN IOVDD_OUT gate_drive_large_0/out IOVDD_IN IOVDD_OUT
+ gate_drive_large_0/out gate_drive_large_0/out IOVDD_OUT IOVDD_IN gate_drive_large_0/out
+ IOVDD_OUT IOVDD_OUT IOVDD_OUT gate_drive_large_0/out gate_drive_large_0/out gate_drive_large_0/out
+ IOVDD_IN IOVDD_OUT gate_drive_large_0/out IOVDD_OUT gate_drive_large_0/out IOVDD_OUT
+ gate_drive_large_0/out gate_drive_large_0/out gate_drive_large_0/out IOVDD_IN gate_drive_large_0/out
+ IOVDD_IN gate_drive_large_0/out IOVDD_OUT IOVDD_OUT gate_drive_large_0/out IOVDD_IN
+ IOVDD_OUT gate_drive_large_0/out IOVDD_IN IOVDD_IN IOVDD_IN IOVDD_IN IOVDD_IN gate_drive_large_0/out
+ gate_drive_large_0/out gate_drive_large_0/out gate_drive_large_0/out IOVDD_OUT gate_drive_large_0/out
+ IOVDD_OUT gate_drive_large_0/out gate_drive_large_0/out IOVDD_IN gate_drive_large_0/out
+ IOVDD_IN IOVDD_OUT IOVDD_OUT gate_drive_large_0/out pfet_05v0_WX3F8K
Xpfet_05v0_WX3F8K_0[3] gate_drive_large_0/out IOVDD_IN IOVDD_OUT gate_drive_large_0/out
+ IOVDD_OUT gate_drive_large_0/out IOVDD_OUT gate_drive_large_0/out IOVDD_OUT gate_drive_large_0/out
+ IOVDD_IN gate_drive_large_0/out IOVDD_IN gate_drive_large_0/out gate_drive_large_0/out
+ gate_drive_large_0/out IOVDD_IN gate_drive_large_0/out IOVDD_IN gate_drive_large_0/out
+ IOVDD_IN gate_drive_large_0/out IOVDD_OUT gate_drive_large_0/out gate_drive_large_0/out
+ IOVDD_OUT gate_drive_large_0/out IOVDD_OUT gate_drive_large_0/out gate_drive_large_0/out
+ gate_drive_large_0/out IOVDD_IN IOVDD_IN gate_drive_large_0/out gate_drive_large_0/out
+ IOVDD_IN IOVDD_IN gate_drive_large_0/out IOVDD_OUT gate_drive_large_0/out gate_drive_large_0/out
+ IOVDD_OUT gate_drive_large_0/out IOVDD_OUT gate_drive_large_0/out IOVDD_OUT gate_drive_large_0/out
+ gate_drive_large_0/out gate_drive_large_0/out gate_drive_large_0/out gate_drive_large_0/out
+ IOVDD_OUT IOVDD_IN gate_drive_large_0/out IOVDD_IN IOVDD_IN IOVDD_OUT IOVDD_OUT
+ IOVDD_IN gate_drive_large_0/out gate_drive_large_0/out IOVDD_IN IOVDD_IN gate_drive_large_0/out
+ gate_drive_large_0/out IOVDD_IN gate_drive_large_0/out IOVDD_OUT gate_drive_large_0/out
+ IOVDD_IN gate_drive_large_0/out IOVDD_IN gate_drive_large_0/out IOVDD_OUT gate_drive_large_0/out
+ IOVDD_IN gate_drive_large_0/out IOVDD_OUT IOVDD_OUT IOVDD_OUT gate_drive_large_0/out
+ IOVDD_OUT IOVDD_OUT gate_drive_large_0/out IOVDD_OUT IOVDD_IN gate_drive_large_0/out
+ IOVDD_IN gate_drive_large_0/out IOVDD_OUT IOVDD_OUT gate_drive_large_0/out gate_drive_large_0/out
+ gate_drive_large_0/out IOVDD_OUT IOVDD_OUT gate_drive_large_0/out IOVDD_OUT gate_drive_large_0/out
+ IOVDD_OUT IOVDD_IN gate_drive_large_0/out gate_drive_large_0/out IOVDD_IN IOVDD_IN
+ gate_drive_large_0/out IOVDD_OUT gate_drive_large_0/out IOVDD_OUT gate_drive_large_0/out
+ IOVDD_OUT IOVDD_OUT gate_drive_large_0/out gate_drive_large_0/out IOVDD_OUT IOVDD_IN
+ gate_drive_large_0/out IOVDD_OUT IOVDD_IN IOVDD_OUT gate_drive_large_0/out IOVDD_IN
+ IOVDD_IN IOVDD_OUT IOVDD_OUT gate_drive_large_0/out gate_drive_large_0/out IOVDD_OUT
+ IOVDD_IN IOVDD_IN IOVDD_IN gate_drive_large_0/out gate_drive_large_0/out gate_drive_large_0/out
+ gate_drive_large_0/out IOVDD_IN IOVDD_OUT gate_drive_large_0/out IOVDD_IN IOVDD_OUT
+ gate_drive_large_0/out gate_drive_large_0/out IOVDD_OUT IOVDD_IN gate_drive_large_0/out
+ IOVDD_OUT IOVDD_OUT IOVDD_OUT gate_drive_large_0/out gate_drive_large_0/out gate_drive_large_0/out
+ IOVDD_IN IOVDD_OUT gate_drive_large_0/out IOVDD_OUT gate_drive_large_0/out IOVDD_OUT
+ gate_drive_large_0/out gate_drive_large_0/out gate_drive_large_0/out IOVDD_IN gate_drive_large_0/out
+ IOVDD_IN gate_drive_large_0/out IOVDD_OUT IOVDD_OUT gate_drive_large_0/out IOVDD_IN
+ IOVDD_OUT gate_drive_large_0/out IOVDD_IN IOVDD_IN IOVDD_IN IOVDD_IN IOVDD_IN gate_drive_large_0/out
+ gate_drive_large_0/out gate_drive_large_0/out gate_drive_large_0/out IOVDD_OUT gate_drive_large_0/out
+ IOVDD_OUT gate_drive_large_0/out gate_drive_large_0/out IOVDD_IN gate_drive_large_0/out
+ IOVDD_IN IOVDD_OUT IOVDD_OUT gate_drive_large_0/out pfet_05v0_WX3F8K
Xpfet_05v0_WX3F8K_0[4] gate_drive_large_0/out IOVDD_IN IOVDD_OUT gate_drive_large_0/out
+ IOVDD_OUT gate_drive_large_0/out IOVDD_OUT gate_drive_large_0/out IOVDD_OUT gate_drive_large_0/out
+ IOVDD_IN gate_drive_large_0/out IOVDD_IN gate_drive_large_0/out gate_drive_large_0/out
+ gate_drive_large_0/out IOVDD_IN gate_drive_large_0/out IOVDD_IN gate_drive_large_0/out
+ IOVDD_IN gate_drive_large_0/out IOVDD_OUT gate_drive_large_0/out gate_drive_large_0/out
+ IOVDD_OUT gate_drive_large_0/out IOVDD_OUT gate_drive_large_0/out gate_drive_large_0/out
+ gate_drive_large_0/out IOVDD_IN IOVDD_IN gate_drive_large_0/out gate_drive_large_0/out
+ IOVDD_IN IOVDD_IN gate_drive_large_0/out IOVDD_OUT gate_drive_large_0/out gate_drive_large_0/out
+ IOVDD_OUT gate_drive_large_0/out IOVDD_OUT gate_drive_large_0/out IOVDD_OUT gate_drive_large_0/out
+ gate_drive_large_0/out gate_drive_large_0/out gate_drive_large_0/out gate_drive_large_0/out
+ IOVDD_OUT IOVDD_IN gate_drive_large_0/out IOVDD_IN IOVDD_IN IOVDD_OUT IOVDD_OUT
+ IOVDD_IN gate_drive_large_0/out gate_drive_large_0/out IOVDD_IN IOVDD_IN gate_drive_large_0/out
+ gate_drive_large_0/out IOVDD_IN gate_drive_large_0/out IOVDD_OUT gate_drive_large_0/out
+ IOVDD_IN gate_drive_large_0/out IOVDD_IN gate_drive_large_0/out IOVDD_OUT gate_drive_large_0/out
+ IOVDD_IN gate_drive_large_0/out IOVDD_OUT IOVDD_OUT IOVDD_OUT gate_drive_large_0/out
+ IOVDD_OUT IOVDD_OUT gate_drive_large_0/out IOVDD_OUT IOVDD_IN gate_drive_large_0/out
+ IOVDD_IN gate_drive_large_0/out IOVDD_OUT IOVDD_OUT gate_drive_large_0/out gate_drive_large_0/out
+ gate_drive_large_0/out IOVDD_OUT IOVDD_OUT gate_drive_large_0/out IOVDD_OUT gate_drive_large_0/out
+ IOVDD_OUT IOVDD_IN gate_drive_large_0/out gate_drive_large_0/out IOVDD_IN IOVDD_IN
+ gate_drive_large_0/out IOVDD_OUT gate_drive_large_0/out IOVDD_OUT gate_drive_large_0/out
+ IOVDD_OUT IOVDD_OUT gate_drive_large_0/out gate_drive_large_0/out IOVDD_OUT IOVDD_IN
+ gate_drive_large_0/out IOVDD_OUT IOVDD_IN IOVDD_OUT gate_drive_large_0/out IOVDD_IN
+ IOVDD_IN IOVDD_OUT IOVDD_OUT gate_drive_large_0/out gate_drive_large_0/out IOVDD_OUT
+ IOVDD_IN IOVDD_IN IOVDD_IN gate_drive_large_0/out gate_drive_large_0/out gate_drive_large_0/out
+ gate_drive_large_0/out IOVDD_IN IOVDD_OUT gate_drive_large_0/out IOVDD_IN IOVDD_OUT
+ gate_drive_large_0/out gate_drive_large_0/out IOVDD_OUT IOVDD_IN gate_drive_large_0/out
+ IOVDD_OUT IOVDD_OUT IOVDD_OUT gate_drive_large_0/out gate_drive_large_0/out gate_drive_large_0/out
+ IOVDD_IN IOVDD_OUT gate_drive_large_0/out IOVDD_OUT gate_drive_large_0/out IOVDD_OUT
+ gate_drive_large_0/out gate_drive_large_0/out gate_drive_large_0/out IOVDD_IN gate_drive_large_0/out
+ IOVDD_IN gate_drive_large_0/out IOVDD_OUT IOVDD_OUT gate_drive_large_0/out IOVDD_IN
+ IOVDD_OUT gate_drive_large_0/out IOVDD_IN IOVDD_IN IOVDD_IN IOVDD_IN IOVDD_IN gate_drive_large_0/out
+ gate_drive_large_0/out gate_drive_large_0/out gate_drive_large_0/out IOVDD_OUT gate_drive_large_0/out
+ IOVDD_OUT gate_drive_large_0/out gate_drive_large_0/out IOVDD_IN gate_drive_large_0/out
+ IOVDD_IN IOVDD_OUT IOVDD_OUT gate_drive_large_0/out pfet_05v0_WX3F8K
Xpfet_05v0_WX3F8K_0[5] gate_drive_large_0/out IOVDD_IN IOVDD_OUT gate_drive_large_0/out
+ IOVDD_OUT gate_drive_large_0/out IOVDD_OUT gate_drive_large_0/out IOVDD_OUT gate_drive_large_0/out
+ IOVDD_IN gate_drive_large_0/out IOVDD_IN gate_drive_large_0/out gate_drive_large_0/out
+ gate_drive_large_0/out IOVDD_IN gate_drive_large_0/out IOVDD_IN gate_drive_large_0/out
+ IOVDD_IN gate_drive_large_0/out IOVDD_OUT gate_drive_large_0/out gate_drive_large_0/out
+ IOVDD_OUT gate_drive_large_0/out IOVDD_OUT gate_drive_large_0/out gate_drive_large_0/out
+ gate_drive_large_0/out IOVDD_IN IOVDD_IN gate_drive_large_0/out gate_drive_large_0/out
+ IOVDD_IN IOVDD_IN gate_drive_large_0/out IOVDD_OUT gate_drive_large_0/out gate_drive_large_0/out
+ IOVDD_OUT gate_drive_large_0/out IOVDD_OUT gate_drive_large_0/out IOVDD_OUT gate_drive_large_0/out
+ gate_drive_large_0/out gate_drive_large_0/out gate_drive_large_0/out gate_drive_large_0/out
+ IOVDD_OUT IOVDD_IN gate_drive_large_0/out IOVDD_IN IOVDD_IN IOVDD_OUT IOVDD_OUT
+ IOVDD_IN gate_drive_large_0/out gate_drive_large_0/out IOVDD_IN IOVDD_IN gate_drive_large_0/out
+ gate_drive_large_0/out IOVDD_IN gate_drive_large_0/out IOVDD_OUT gate_drive_large_0/out
+ IOVDD_IN gate_drive_large_0/out IOVDD_IN gate_drive_large_0/out IOVDD_OUT gate_drive_large_0/out
+ IOVDD_IN gate_drive_large_0/out IOVDD_OUT IOVDD_OUT IOVDD_OUT gate_drive_large_0/out
+ IOVDD_OUT IOVDD_OUT gate_drive_large_0/out IOVDD_OUT IOVDD_IN gate_drive_large_0/out
+ IOVDD_IN gate_drive_large_0/out IOVDD_OUT IOVDD_OUT gate_drive_large_0/out gate_drive_large_0/out
+ gate_drive_large_0/out IOVDD_OUT IOVDD_OUT gate_drive_large_0/out IOVDD_OUT gate_drive_large_0/out
+ IOVDD_OUT IOVDD_IN gate_drive_large_0/out gate_drive_large_0/out IOVDD_IN IOVDD_IN
+ gate_drive_large_0/out IOVDD_OUT gate_drive_large_0/out IOVDD_OUT gate_drive_large_0/out
+ IOVDD_OUT IOVDD_OUT gate_drive_large_0/out gate_drive_large_0/out IOVDD_OUT IOVDD_IN
+ gate_drive_large_0/out IOVDD_OUT IOVDD_IN IOVDD_OUT gate_drive_large_0/out IOVDD_IN
+ IOVDD_IN IOVDD_OUT IOVDD_OUT gate_drive_large_0/out gate_drive_large_0/out IOVDD_OUT
+ IOVDD_IN IOVDD_IN IOVDD_IN gate_drive_large_0/out gate_drive_large_0/out gate_drive_large_0/out
+ gate_drive_large_0/out IOVDD_IN IOVDD_OUT gate_drive_large_0/out IOVDD_IN IOVDD_OUT
+ gate_drive_large_0/out gate_drive_large_0/out IOVDD_OUT IOVDD_IN gate_drive_large_0/out
+ IOVDD_OUT IOVDD_OUT IOVDD_OUT gate_drive_large_0/out gate_drive_large_0/out gate_drive_large_0/out
+ IOVDD_IN IOVDD_OUT gate_drive_large_0/out IOVDD_OUT gate_drive_large_0/out IOVDD_OUT
+ gate_drive_large_0/out gate_drive_large_0/out gate_drive_large_0/out IOVDD_IN gate_drive_large_0/out
+ IOVDD_IN gate_drive_large_0/out IOVDD_OUT IOVDD_OUT gate_drive_large_0/out IOVDD_IN
+ IOVDD_OUT gate_drive_large_0/out IOVDD_IN IOVDD_IN IOVDD_IN IOVDD_IN IOVDD_IN gate_drive_large_0/out
+ gate_drive_large_0/out gate_drive_large_0/out gate_drive_large_0/out IOVDD_OUT gate_drive_large_0/out
+ IOVDD_OUT gate_drive_large_0/out gate_drive_large_0/out IOVDD_IN gate_drive_large_0/out
+ IOVDD_IN IOVDD_OUT IOVDD_OUT gate_drive_large_0/out pfet_05v0_WX3F8K
Xpfet_05v0_WX3F8K_0[6] gate_drive_large_0/out IOVDD_IN IOVDD_OUT gate_drive_large_0/out
+ IOVDD_OUT gate_drive_large_0/out IOVDD_OUT gate_drive_large_0/out IOVDD_OUT gate_drive_large_0/out
+ IOVDD_IN gate_drive_large_0/out IOVDD_IN gate_drive_large_0/out gate_drive_large_0/out
+ gate_drive_large_0/out IOVDD_IN gate_drive_large_0/out IOVDD_IN gate_drive_large_0/out
+ IOVDD_IN gate_drive_large_0/out IOVDD_OUT gate_drive_large_0/out gate_drive_large_0/out
+ IOVDD_OUT gate_drive_large_0/out IOVDD_OUT gate_drive_large_0/out gate_drive_large_0/out
+ gate_drive_large_0/out IOVDD_IN IOVDD_IN gate_drive_large_0/out gate_drive_large_0/out
+ IOVDD_IN IOVDD_IN gate_drive_large_0/out IOVDD_OUT gate_drive_large_0/out gate_drive_large_0/out
+ IOVDD_OUT gate_drive_large_0/out IOVDD_OUT gate_drive_large_0/out IOVDD_OUT gate_drive_large_0/out
+ gate_drive_large_0/out gate_drive_large_0/out gate_drive_large_0/out gate_drive_large_0/out
+ IOVDD_OUT IOVDD_IN gate_drive_large_0/out IOVDD_IN IOVDD_IN IOVDD_OUT IOVDD_OUT
+ IOVDD_IN gate_drive_large_0/out gate_drive_large_0/out IOVDD_IN IOVDD_IN gate_drive_large_0/out
+ gate_drive_large_0/out IOVDD_IN gate_drive_large_0/out IOVDD_OUT gate_drive_large_0/out
+ IOVDD_IN gate_drive_large_0/out IOVDD_IN gate_drive_large_0/out IOVDD_OUT gate_drive_large_0/out
+ IOVDD_IN gate_drive_large_0/out IOVDD_OUT IOVDD_OUT IOVDD_OUT gate_drive_large_0/out
+ IOVDD_OUT IOVDD_OUT gate_drive_large_0/out IOVDD_OUT IOVDD_IN gate_drive_large_0/out
+ IOVDD_IN gate_drive_large_0/out IOVDD_OUT IOVDD_OUT gate_drive_large_0/out gate_drive_large_0/out
+ gate_drive_large_0/out IOVDD_OUT IOVDD_OUT gate_drive_large_0/out IOVDD_OUT gate_drive_large_0/out
+ IOVDD_OUT IOVDD_IN gate_drive_large_0/out gate_drive_large_0/out IOVDD_IN IOVDD_IN
+ gate_drive_large_0/out IOVDD_OUT gate_drive_large_0/out IOVDD_OUT gate_drive_large_0/out
+ IOVDD_OUT IOVDD_OUT gate_drive_large_0/out gate_drive_large_0/out IOVDD_OUT IOVDD_IN
+ gate_drive_large_0/out IOVDD_OUT IOVDD_IN IOVDD_OUT gate_drive_large_0/out IOVDD_IN
+ IOVDD_IN IOVDD_OUT IOVDD_OUT gate_drive_large_0/out gate_drive_large_0/out IOVDD_OUT
+ IOVDD_IN IOVDD_IN IOVDD_IN gate_drive_large_0/out gate_drive_large_0/out gate_drive_large_0/out
+ gate_drive_large_0/out IOVDD_IN IOVDD_OUT gate_drive_large_0/out IOVDD_IN IOVDD_OUT
+ gate_drive_large_0/out gate_drive_large_0/out IOVDD_OUT IOVDD_IN gate_drive_large_0/out
+ IOVDD_OUT IOVDD_OUT IOVDD_OUT gate_drive_large_0/out gate_drive_large_0/out gate_drive_large_0/out
+ IOVDD_IN IOVDD_OUT gate_drive_large_0/out IOVDD_OUT gate_drive_large_0/out IOVDD_OUT
+ gate_drive_large_0/out gate_drive_large_0/out gate_drive_large_0/out IOVDD_IN gate_drive_large_0/out
+ IOVDD_IN gate_drive_large_0/out IOVDD_OUT IOVDD_OUT gate_drive_large_0/out IOVDD_IN
+ IOVDD_OUT gate_drive_large_0/out IOVDD_IN IOVDD_IN IOVDD_IN IOVDD_IN IOVDD_IN gate_drive_large_0/out
+ gate_drive_large_0/out gate_drive_large_0/out gate_drive_large_0/out IOVDD_OUT gate_drive_large_0/out
+ IOVDD_OUT gate_drive_large_0/out gate_drive_large_0/out IOVDD_IN gate_drive_large_0/out
+ IOVDD_IN IOVDD_OUT IOVDD_OUT gate_drive_large_0/out pfet_05v0_WX3F8K
Xpfet_05v0_WX3F8K_0[7] gate_drive_large_0/out IOVDD_IN IOVDD_OUT gate_drive_large_0/out
+ IOVDD_OUT gate_drive_large_0/out IOVDD_OUT gate_drive_large_0/out IOVDD_OUT gate_drive_large_0/out
+ IOVDD_IN gate_drive_large_0/out IOVDD_IN gate_drive_large_0/out gate_drive_large_0/out
+ gate_drive_large_0/out IOVDD_IN gate_drive_large_0/out IOVDD_IN gate_drive_large_0/out
+ IOVDD_IN gate_drive_large_0/out IOVDD_OUT gate_drive_large_0/out gate_drive_large_0/out
+ IOVDD_OUT gate_drive_large_0/out IOVDD_OUT gate_drive_large_0/out gate_drive_large_0/out
+ gate_drive_large_0/out IOVDD_IN IOVDD_IN gate_drive_large_0/out gate_drive_large_0/out
+ IOVDD_IN IOVDD_IN gate_drive_large_0/out IOVDD_OUT gate_drive_large_0/out gate_drive_large_0/out
+ IOVDD_OUT gate_drive_large_0/out IOVDD_OUT gate_drive_large_0/out IOVDD_OUT gate_drive_large_0/out
+ gate_drive_large_0/out gate_drive_large_0/out gate_drive_large_0/out gate_drive_large_0/out
+ IOVDD_OUT IOVDD_IN gate_drive_large_0/out IOVDD_IN IOVDD_IN IOVDD_OUT IOVDD_OUT
+ IOVDD_IN gate_drive_large_0/out gate_drive_large_0/out IOVDD_IN IOVDD_IN gate_drive_large_0/out
+ gate_drive_large_0/out IOVDD_IN gate_drive_large_0/out IOVDD_OUT gate_drive_large_0/out
+ IOVDD_IN gate_drive_large_0/out IOVDD_IN gate_drive_large_0/out IOVDD_OUT gate_drive_large_0/out
+ IOVDD_IN gate_drive_large_0/out IOVDD_OUT IOVDD_OUT IOVDD_OUT gate_drive_large_0/out
+ IOVDD_OUT IOVDD_OUT gate_drive_large_0/out IOVDD_OUT IOVDD_IN gate_drive_large_0/out
+ IOVDD_IN gate_drive_large_0/out IOVDD_OUT IOVDD_OUT gate_drive_large_0/out gate_drive_large_0/out
+ gate_drive_large_0/out IOVDD_OUT IOVDD_OUT gate_drive_large_0/out IOVDD_OUT gate_drive_large_0/out
+ IOVDD_OUT IOVDD_IN gate_drive_large_0/out gate_drive_large_0/out IOVDD_IN IOVDD_IN
+ gate_drive_large_0/out IOVDD_OUT gate_drive_large_0/out IOVDD_OUT gate_drive_large_0/out
+ IOVDD_OUT IOVDD_OUT gate_drive_large_0/out gate_drive_large_0/out IOVDD_OUT IOVDD_IN
+ gate_drive_large_0/out IOVDD_OUT IOVDD_IN IOVDD_OUT gate_drive_large_0/out IOVDD_IN
+ IOVDD_IN IOVDD_OUT IOVDD_OUT gate_drive_large_0/out gate_drive_large_0/out IOVDD_OUT
+ IOVDD_IN IOVDD_IN IOVDD_IN gate_drive_large_0/out gate_drive_large_0/out gate_drive_large_0/out
+ gate_drive_large_0/out IOVDD_IN IOVDD_OUT gate_drive_large_0/out IOVDD_IN IOVDD_OUT
+ gate_drive_large_0/out gate_drive_large_0/out IOVDD_OUT IOVDD_IN gate_drive_large_0/out
+ IOVDD_OUT IOVDD_OUT IOVDD_OUT gate_drive_large_0/out gate_drive_large_0/out gate_drive_large_0/out
+ IOVDD_IN IOVDD_OUT gate_drive_large_0/out IOVDD_OUT gate_drive_large_0/out IOVDD_OUT
+ gate_drive_large_0/out gate_drive_large_0/out gate_drive_large_0/out IOVDD_IN gate_drive_large_0/out
+ IOVDD_IN gate_drive_large_0/out IOVDD_OUT IOVDD_OUT gate_drive_large_0/out IOVDD_IN
+ IOVDD_OUT gate_drive_large_0/out IOVDD_IN IOVDD_IN IOVDD_IN IOVDD_IN IOVDD_IN gate_drive_large_0/out
+ gate_drive_large_0/out gate_drive_large_0/out gate_drive_large_0/out IOVDD_OUT gate_drive_large_0/out
+ IOVDD_OUT gate_drive_large_0/out gate_drive_large_0/out IOVDD_IN gate_drive_large_0/out
+ IOVDD_IN IOVDD_OUT IOVDD_OUT gate_drive_large_0/out pfet_05v0_WX3F8K
Xgf180mcu_as_sc_mcu7t3v3__fillcap_4_0 DVDD gf180mcu_as_sc_mcu7t3v3__inv_4_1/VNW gf180mcu_as_sc_mcu7t3v3__inv_4_1/VPW
+ DVSS gf180mcu_as_sc_mcu7t3v3__fillcap_4
Xgf180mcu_as_sc_mcu7t3v3__inv_4_0 DVDD gf180mcu_as_sc_mcu7t3v3__inv_4_1/VNW gf180mcu_as_sc_mcu7t3v3__inv_4_1/VPW
+ DVSS gate_drive_large_0/in_p enable gf180mcu_as_sc_mcu7t3v3__inv_4
Xgf180mcu_as_sc_mcu7t3v3__fillcap_4_1 DVDD gf180mcu_as_sc_mcu7t3v3__inv_4_1/VNW gf180mcu_as_sc_mcu7t3v3__inv_4_1/VPW
+ DVSS gf180mcu_as_sc_mcu7t3v3__fillcap_4
Xgf180mcu_as_sc_mcu7t3v3__inv_4_1 DVDD gf180mcu_as_sc_mcu7t3v3__inv_4_1/VNW gf180mcu_as_sc_mcu7t3v3__inv_4_1/VPW
+ DVSS gate_drive_large_0/in_n gate_drive_large_0/in_p gf180mcu_as_sc_mcu7t3v3__inv_4
Xgf180mcu_as_sc_mcu7t3v3__diode_2_0 DVDD gf180mcu_as_sc_mcu7t3v3__inv_4_1/VNW gf180mcu_as_sc_mcu7t3v3__inv_4_1/VPW
+ DVSS enable gf180mcu_as_sc_mcu7t3v3__diode_2
Xgate_drive_large_0 gate_drive_large_0/in_p gate_drive_large_0/in_n gate_drive_large_0/out
+ gate_drive_large_0/outn IOVSS IOVDD_IN gate_drive_large
.ends
