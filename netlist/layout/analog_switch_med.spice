* NGSPICE file created from analog_switch_med.ext - technology: gf180mcuD

.subckt gf180mcu_as_sc_mcu7t3v3__fillcap_4 VDD VNW VPW VSS
X0 a_126_408# a_28_500# VSS VPW nfet_03v3 ad=0.44p pd=2.88u as=0.49p ps=2.98u w=1u l=1.03u
X1 VDD a_126_408# a_28_500# VNW pfet_03v3 ad=0.4752p pd=3.04u as=0.5292p ps=3.14u w=1.08u l=1.03u
.ends

.subckt gf180mcu_as_sc_mcu7t3v3__inv_4 VDD VNW VPW VSS Y A
X0 VDD A Y VNW pfet_03v3 ad=0.3588p pd=1.9u as=0.3588p ps=1.9u w=1.38u l=0.28u
X1 Y A VSS VPW nfet_03v3 ad=0.26p pd=1.52u as=0.44p ps=2.88u w=1u l=0.28u
X2 Y A VDD VNW pfet_03v3 ad=0.3588p pd=1.9u as=0.3588p ps=1.9u w=1.38u l=0.28u
X3 VSS A Y VPW nfet_03v3 ad=0.52p pd=3.04u as=0.26p ps=1.52u w=1u l=0.28u
X4 VDD A Y VNW pfet_03v3 ad=0.7176p pd=3.8u as=0.3588p ps=1.9u w=1.38u l=0.28u
X5 Y A VSS VPW nfet_03v3 ad=0.26p pd=1.52u as=0.26p ps=1.52u w=1u l=0.28u
X6 Y A VDD VNW pfet_03v3 ad=0.3588p pd=1.9u as=0.6072p ps=3.64u w=1.38u l=0.28u
X7 VSS A Y VPW nfet_03v3 ad=0.26p pd=1.52u as=0.26p ps=1.52u w=1u l=0.28u
.ends

.subckt pfet_05v0_6SLWPD a_254_n1200# a_358_n3924# a_n766_n1200# a_254_1432# a_n766_1432#
+ a_766_1340# a_662_n3832# a_n254_n3924# a_n50_1340# a_n1070_1340# a_50_n3832# a_n50_n3924#
+ a_n866_1340# a_154_n3924# a_458_n3832# a_n562_n1200# a_n970_1432# a_970_1340# a_n970_n3832#
+ a_n358_n1200# a_254_n3832# a_1274_1432# a_n358_1432# a_n1362_1432# a_358_1340# a_n766_n3832#
+ a_970_n1292# a_n866_n1292# a_1274_n1200# a_n1362_n1200# a_n1274_n3924# a_n154_n1200#
+ a_766_n1292# a_n458_1340# a_n562_1432# a_562_1340# a_n562_n3832# a_n662_n1292# a_1070_n1200#
+ a_50_1432# a_n358_n3832# a_1174_n3924# a_n1070_n3924# a_562_n1292# a_n458_n1292#
+ a_866_1432# a_n662_1340# a_358_n1292# a_n1362_n3832# a_1274_n3832# a_n154_n3832#
+ a_n1174_n1200# a_n254_n1292# a_1070_1432# a_n154_1432# a_154_1340# a_n50_n1292#
+ a_n1174_1432# a_154_n1292# a_1070_n3832# a_866_n1200# a_458_1432# a_n254_1340# a_n1274_1340#
+ a_970_n3924# a_n866_n3924# w_n1538_n4088# a_766_n3924# a_662_n1200# a_662_1432#
+ a_1174_1340# a_50_n1200# a_n1274_n1292# a_n1174_n3832# a_n662_n3924# a_458_n1200#
+ a_562_n3924# a_866_n3832# a_n458_n3924# a_n970_n1200# a_1174_n1292# a_n1070_n1292#
X0 a_n970_n3832# a_n1070_n3924# a_n1174_n3832# w_n1538_n4088# pfet_05v0 ad=3.12p pd=12.52u as=3.12p ps=12.52u w=12u l=0.5u
X1 a_1274_n3832# a_1174_n3924# a_1070_n3832# w_n1538_n4088# pfet_05v0 ad=5.28p pd=24.88u as=3.12p ps=12.52u w=12u l=0.5u
X2 a_n154_1432# a_n254_1340# a_n358_1432# w_n1538_n4088# pfet_05v0 ad=3.12p pd=12.52u as=3.12p ps=12.52u w=12u l=0.5u
X3 a_n1174_1432# a_n1274_1340# a_n1362_1432# w_n1538_n4088# pfet_05v0 ad=3.12p pd=12.52u as=5.28p ps=24.88u w=12u l=0.5u
X4 a_1274_1432# a_1174_1340# a_1070_1432# w_n1538_n4088# pfet_05v0 ad=5.28p pd=24.88u as=3.12p ps=12.52u w=12u l=0.5u
X5 a_n970_n1200# a_n1070_n1292# a_n1174_n1200# w_n1538_n4088# pfet_05v0 ad=3.12p pd=12.52u as=3.12p ps=12.52u w=12u l=0.5u
X6 a_1274_n1200# a_1174_n1292# a_1070_n1200# w_n1538_n4088# pfet_05v0 ad=5.28p pd=24.88u as=3.12p ps=12.52u w=12u l=0.5u
X7 a_50_1432# a_n50_1340# a_n154_1432# w_n1538_n4088# pfet_05v0 ad=3.12p pd=12.52u as=3.12p ps=12.52u w=12u l=0.5u
X8 a_254_1432# a_154_1340# a_50_1432# w_n1538_n4088# pfet_05v0 ad=3.12p pd=12.52u as=3.12p ps=12.52u w=12u l=0.5u
X9 a_866_n3832# a_766_n3924# a_662_n3832# w_n1538_n4088# pfet_05v0 ad=3.12p pd=12.52u as=3.12p ps=12.52u w=12u l=0.5u
X10 a_458_n3832# a_358_n3924# a_254_n3832# w_n1538_n4088# pfet_05v0 ad=3.12p pd=12.52u as=3.12p ps=12.52u w=12u l=0.5u
X11 a_n562_1432# a_n662_1340# a_n766_1432# w_n1538_n4088# pfet_05v0 ad=3.12p pd=12.52u as=3.12p ps=12.52u w=12u l=0.5u
X12 a_458_n1200# a_358_n1292# a_254_n1200# w_n1538_n4088# pfet_05v0 ad=3.12p pd=12.52u as=3.12p ps=12.52u w=12u l=0.5u
X13 a_866_n1200# a_766_n1292# a_662_n1200# w_n1538_n4088# pfet_05v0 ad=3.12p pd=12.52u as=3.12p ps=12.52u w=12u l=0.5u
X14 a_n970_1432# a_n1070_1340# a_n1174_1432# w_n1538_n4088# pfet_05v0 ad=3.12p pd=12.52u as=3.12p ps=12.52u w=12u l=0.5u
X15 a_662_1432# a_562_1340# a_458_1432# w_n1538_n4088# pfet_05v0 ad=3.12p pd=12.52u as=3.12p ps=12.52u w=12u l=0.5u
X16 a_n1174_n3832# a_n1274_n3924# a_n1362_n3832# w_n1538_n4088# pfet_05v0 ad=3.12p pd=12.52u as=5.28p ps=24.88u w=12u l=0.5u
X17 a_n766_n3832# a_n866_n3924# a_n970_n3832# w_n1538_n4088# pfet_05v0 ad=3.12p pd=12.52u as=3.12p ps=12.52u w=12u l=0.5u
X18 a_n358_n3832# a_n458_n3924# a_n562_n3832# w_n1538_n4088# pfet_05v0 ad=3.12p pd=12.52u as=3.12p ps=12.52u w=12u l=0.5u
X19 a_n1174_n1200# a_n1274_n1292# a_n1362_n1200# w_n1538_n4088# pfet_05v0 ad=3.12p pd=12.52u as=5.28p ps=24.88u w=12u l=0.5u
X20 a_n766_n1200# a_n866_n1292# a_n970_n1200# w_n1538_n4088# pfet_05v0 ad=3.12p pd=12.52u as=3.12p ps=12.52u w=12u l=0.5u
X21 a_n358_n1200# a_n458_n1292# a_n562_n1200# w_n1538_n4088# pfet_05v0 ad=3.12p pd=12.52u as=3.12p ps=12.52u w=12u l=0.5u
X22 a_n358_1432# a_n458_1340# a_n562_1432# w_n1538_n4088# pfet_05v0 ad=3.12p pd=12.52u as=3.12p ps=12.52u w=12u l=0.5u
X23 a_662_n3832# a_562_n3924# a_458_n3832# w_n1538_n4088# pfet_05v0 ad=3.12p pd=12.52u as=3.12p ps=12.52u w=12u l=0.5u
X24 a_1070_n3832# a_970_n3924# a_866_n3832# w_n1538_n4088# pfet_05v0 ad=3.12p pd=12.52u as=3.12p ps=12.52u w=12u l=0.5u
X25 a_254_n3832# a_154_n3924# a_50_n3832# w_n1538_n4088# pfet_05v0 ad=3.12p pd=12.52u as=3.12p ps=12.52u w=12u l=0.5u
X26 a_458_1432# a_358_1340# a_254_1432# w_n1538_n4088# pfet_05v0 ad=3.12p pd=12.52u as=3.12p ps=12.52u w=12u l=0.5u
X27 a_1070_1432# a_970_1340# a_866_1432# w_n1538_n4088# pfet_05v0 ad=3.12p pd=12.52u as=3.12p ps=12.52u w=12u l=0.5u
X28 a_254_n1200# a_154_n1292# a_50_n1200# w_n1538_n4088# pfet_05v0 ad=3.12p pd=12.52u as=3.12p ps=12.52u w=12u l=0.5u
X29 a_662_n1200# a_562_n1292# a_458_n1200# w_n1538_n4088# pfet_05v0 ad=3.12p pd=12.52u as=3.12p ps=12.52u w=12u l=0.5u
X30 a_1070_n1200# a_970_n1292# a_866_n1200# w_n1538_n4088# pfet_05v0 ad=3.12p pd=12.52u as=3.12p ps=12.52u w=12u l=0.5u
X31 a_50_n3832# a_n50_n3924# a_n154_n3832# w_n1538_n4088# pfet_05v0 ad=3.12p pd=12.52u as=3.12p ps=12.52u w=12u l=0.5u
X32 a_n766_1432# a_n866_1340# a_n970_1432# w_n1538_n4088# pfet_05v0 ad=3.12p pd=12.52u as=3.12p ps=12.52u w=12u l=0.5u
X33 a_n562_n3832# a_n662_n3924# a_n766_n3832# w_n1538_n4088# pfet_05v0 ad=3.12p pd=12.52u as=3.12p ps=12.52u w=12u l=0.5u
X34 a_n154_n3832# a_n254_n3924# a_n358_n3832# w_n1538_n4088# pfet_05v0 ad=3.12p pd=12.52u as=3.12p ps=12.52u w=12u l=0.5u
X35 a_50_n1200# a_n50_n1292# a_n154_n1200# w_n1538_n4088# pfet_05v0 ad=3.12p pd=12.52u as=3.12p ps=12.52u w=12u l=0.5u
X36 a_866_1432# a_766_1340# a_662_1432# w_n1538_n4088# pfet_05v0 ad=3.12p pd=12.52u as=3.12p ps=12.52u w=12u l=0.5u
X37 a_n562_n1200# a_n662_n1292# a_n766_n1200# w_n1538_n4088# pfet_05v0 ad=3.12p pd=12.52u as=3.12p ps=12.52u w=12u l=0.5u
X38 a_n154_n1200# a_n254_n1292# a_n358_n1200# w_n1538_n4088# pfet_05v0 ad=3.12p pd=12.52u as=3.12p ps=12.52u w=12u l=0.5u
.ends

.subckt gf180mcu_as_sc_mcu7t3v3__diode_2 VDD VNW VPW VSS DIODE
D0 DIODE VNW diode_pd2nw_03v3 pj=1.93u area=0.2295p
D1 VPW DIODE diode_nd2ps_03v3 pj=1.83u area=0.209p
.ends

.subckt nfet_05v0_VPM4SY a_956_n3832# a_1284_n3924# a_n1180_n3924# a_1180_n1200# a_n388_n1200#
+ a_1404_1432# a_284_n3832# a_n1060_n3832# a_60_n1200# a_1404_n1200# a_1060_n1292#
+ a_n1180_1340# a_508_n3832# a_n1404_n3924# a_n612_n1200# a_n1284_n1200# a_n284_1340#
+ a_n1636_n4056# a_1180_n3832# a_n388_n3832# a_60_1432# a_n732_1340# a_388_n1292#
+ a_n956_n1292# a_60_n3832# a_836_n3924# a_n60_n3924# a_732_n1200# a_n284_n1292# a_164_n3924#
+ a_n1492_n1200# a_1404_n3832# a_n732_n3924# a_n164_1432# a_n1060_1432# a_164_1340#
+ a_n612_n3832# a_n1284_n3832# a_612_n1292# a_n508_1340# a_n1404_1340# a_n508_n1292#
+ a_284_1432# a_1284_n1292# a_n1180_n1292# a_n612_1432# a_612_1340# a_n956_1340# a_n836_n1200#
+ a_732_n3832# a_n164_n1200# a_732_1432# a_1060_1340# a_n1492_n3832# a_1060_n3924#
+ a_n1404_n1292# a_1180_1432# a_956_n1200# a_n388_1432# a_n1284_1432# a_388_1340#
+ a_284_n1200# a_n1060_n1200# a_388_n3924# a_n836_n3832# a_n956_n3924# a_n836_1432#
+ a_836_1340# a_n164_n3832# a_n284_n3924# a_508_1432# a_836_n1292# a_n60_n1292# a_956_1432#
+ a_n60_1340# a_508_n1200# a_164_n1292# a_1284_1340# a_n732_n1292# a_612_n3924# a_n508_n3924#
+ a_n1492_1432#
X0 a_n164_n3832# a_n284_n3924# a_n388_n3832# a_n1636_n4056# nfet_05v0 ad=3.12p pd=12.52u as=3.12p ps=12.52u w=12u l=0.6u
X1 a_n164_1432# a_n284_1340# a_n388_1432# a_n1636_n4056# nfet_05v0 ad=3.12p pd=12.52u as=3.12p ps=12.52u w=12u l=0.6u
X2 a_n164_n1200# a_n284_n1292# a_n388_n1200# a_n1636_n4056# nfet_05v0 ad=3.12p pd=12.52u as=3.12p ps=12.52u w=12u l=0.6u
X3 a_284_n3832# a_164_n3924# a_60_n3832# a_n1636_n4056# nfet_05v0 ad=3.12p pd=12.52u as=3.12p ps=12.52u w=12u l=0.6u
X4 a_n612_n3832# a_n732_n3924# a_n836_n3832# a_n1636_n4056# nfet_05v0 ad=3.12p pd=12.52u as=3.12p ps=12.52u w=12u l=0.6u
X5 a_284_n1200# a_164_n1292# a_60_n1200# a_n1636_n4056# nfet_05v0 ad=3.12p pd=12.52u as=3.12p ps=12.52u w=12u l=0.6u
X6 a_60_n3832# a_n60_n3924# a_n164_n3832# a_n1636_n4056# nfet_05v0 ad=3.12p pd=12.52u as=3.12p ps=12.52u w=12u l=0.6u
X7 a_508_n3832# a_388_n3924# a_284_n3832# a_n1636_n4056# nfet_05v0 ad=3.12p pd=12.52u as=3.12p ps=12.52u w=12u l=0.6u
X8 a_956_1432# a_836_1340# a_732_1432# a_n1636_n4056# nfet_05v0 ad=3.12p pd=12.52u as=3.12p ps=12.52u w=12u l=0.6u
X9 a_1404_1432# a_1284_1340# a_1180_1432# a_n1636_n4056# nfet_05v0 ad=5.28p pd=24.88u as=3.12p ps=12.52u w=12u l=0.6u
X10 a_n612_n1200# a_n732_n1292# a_n836_n1200# a_n1636_n4056# nfet_05v0 ad=3.12p pd=12.52u as=3.12p ps=12.52u w=12u l=0.6u
X11 a_n388_n3832# a_n508_n3924# a_n612_n3832# a_n1636_n4056# nfet_05v0 ad=3.12p pd=12.52u as=3.12p ps=12.52u w=12u l=0.6u
X12 a_1180_n3832# a_1060_n3924# a_956_n3832# a_n1636_n4056# nfet_05v0 ad=3.12p pd=12.52u as=3.12p ps=12.52u w=12u l=0.6u
X13 a_60_n1200# a_n60_n1292# a_n164_n1200# a_n1636_n4056# nfet_05v0 ad=3.12p pd=12.52u as=3.12p ps=12.52u w=12u l=0.6u
X14 a_n836_n3832# a_n956_n3924# a_n1060_n3832# a_n1636_n4056# nfet_05v0 ad=3.12p pd=12.52u as=3.12p ps=12.52u w=12u l=0.6u
X15 a_508_n1200# a_388_n1292# a_284_n1200# a_n1636_n4056# nfet_05v0 ad=3.12p pd=12.52u as=3.12p ps=12.52u w=12u l=0.6u
X16 a_732_1432# a_612_1340# a_508_1432# a_n1636_n4056# nfet_05v0 ad=3.12p pd=12.52u as=3.12p ps=12.52u w=12u l=0.6u
X17 a_1180_1432# a_1060_1340# a_956_1432# a_n1636_n4056# nfet_05v0 ad=3.12p pd=12.52u as=3.12p ps=12.52u w=12u l=0.6u
X18 a_n836_n1200# a_n956_n1292# a_n1060_n1200# a_n1636_n4056# nfet_05v0 ad=3.12p pd=12.52u as=3.12p ps=12.52u w=12u l=0.6u
X19 a_n388_n1200# a_n508_n1292# a_n612_n1200# a_n1636_n4056# nfet_05v0 ad=3.12p pd=12.52u as=3.12p ps=12.52u w=12u l=0.6u
X20 a_1180_n1200# a_1060_n1292# a_956_n1200# a_n1636_n4056# nfet_05v0 ad=3.12p pd=12.52u as=3.12p ps=12.52u w=12u l=0.6u
X21 a_n1060_n3832# a_n1180_n3924# a_n1284_n3832# a_n1636_n4056# nfet_05v0 ad=3.12p pd=12.52u as=3.12p ps=12.52u w=12u l=0.6u
X22 a_1404_n3832# a_1284_n3924# a_1180_n3832# a_n1636_n4056# nfet_05v0 ad=5.28p pd=24.88u as=3.12p ps=12.52u w=12u l=0.6u
X23 a_n1284_1432# a_n1404_1340# a_n1492_1432# a_n1636_n4056# nfet_05v0 ad=3.12p pd=12.52u as=5.28p ps=24.88u w=12u l=0.6u
X24 a_732_n3832# a_612_n3924# a_508_n3832# a_n1636_n4056# nfet_05v0 ad=3.12p pd=12.52u as=3.12p ps=12.52u w=12u l=0.6u
X25 a_508_1432# a_388_1340# a_284_1432# a_n1636_n4056# nfet_05v0 ad=3.12p pd=12.52u as=3.12p ps=12.52u w=12u l=0.6u
X26 a_n1060_n1200# a_n1180_n1292# a_n1284_n1200# a_n1636_n4056# nfet_05v0 ad=3.12p pd=12.52u as=3.12p ps=12.52u w=12u l=0.6u
X27 a_1404_n1200# a_1284_n1292# a_1180_n1200# a_n1636_n4056# nfet_05v0 ad=5.28p pd=24.88u as=3.12p ps=12.52u w=12u l=0.6u
X28 a_n1060_1432# a_n1180_1340# a_n1284_1432# a_n1636_n4056# nfet_05v0 ad=3.12p pd=12.52u as=3.12p ps=12.52u w=12u l=0.6u
X29 a_n388_1432# a_n508_1340# a_n612_1432# a_n1636_n4056# nfet_05v0 ad=3.12p pd=12.52u as=3.12p ps=12.52u w=12u l=0.6u
X30 a_732_n1200# a_612_n1292# a_508_n1200# a_n1636_n4056# nfet_05v0 ad=3.12p pd=12.52u as=3.12p ps=12.52u w=12u l=0.6u
X31 a_n836_1432# a_n956_1340# a_n1060_1432# a_n1636_n4056# nfet_05v0 ad=3.12p pd=12.52u as=3.12p ps=12.52u w=12u l=0.6u
X32 a_60_1432# a_n60_1340# a_n164_1432# a_n1636_n4056# nfet_05v0 ad=3.12p pd=12.52u as=3.12p ps=12.52u w=12u l=0.6u
X33 a_284_1432# a_164_1340# a_60_1432# a_n1636_n4056# nfet_05v0 ad=3.12p pd=12.52u as=3.12p ps=12.52u w=12u l=0.6u
X34 a_956_n3832# a_836_n3924# a_732_n3832# a_n1636_n4056# nfet_05v0 ad=3.12p pd=12.52u as=3.12p ps=12.52u w=12u l=0.6u
X35 a_n1284_n3832# a_n1404_n3924# a_n1492_n3832# a_n1636_n4056# nfet_05v0 ad=3.12p pd=12.52u as=5.28p ps=24.88u w=12u l=0.6u
X36 a_956_n1200# a_836_n1292# a_732_n1200# a_n1636_n4056# nfet_05v0 ad=3.12p pd=12.52u as=3.12p ps=12.52u w=12u l=0.6u
X37 a_n612_1432# a_n732_1340# a_n836_1432# a_n1636_n4056# nfet_05v0 ad=3.12p pd=12.52u as=3.12p ps=12.52u w=12u l=0.6u
X38 a_n1284_n1200# a_n1404_n1292# a_n1492_n1200# a_n1636_n4056# nfet_05v0 ad=3.12p pd=12.52u as=5.28p ps=24.88u w=12u l=0.6u
.ends

.subckt nfet_05v0_C5JAWQ a_n332_n200# a_n244_n292# a_36_n200# a_n124_n200# a_244_n200#
+ a_124_n292# VSUBS
X0 a_244_n200# a_124_n292# a_36_n200# VSUBS nfet_05v0 ad=0.88p pd=4.88u as=0.88p ps=4.88u w=2u l=0.6u
X1 a_n124_n200# a_n244_n292# a_n332_n200# VSUBS nfet_05v0 ad=0.88p pd=4.88u as=0.88p ps=4.88u w=2u l=0.6u
.ends

.subckt pfet_06v0_2T3SUY a_1516_n1000# a_1172_n1092# a_n724_n1000# a_n1396_n1000#
+ a_2964_n1092# a_n2188_n1092# a_n2860_n1092# a_2636_n1000# a_2292_n1092# a_n4308_n1000#
+ a_n3980_n1092# a_3756_n1000# a_52_n1092# a_3084_n1000# a_n2412_n1092# a_844_n1000#
+ a_n1620_n1000# a_2516_n1092# a_n396_n1092# a_172_n1000# a_n2068_n1000# a_3636_n1092#
+ a_n3532_n1092# a_3308_n1000# a_n2740_n1000# w_n4602_n1178# a_n3188_n1000# a_n3860_n1000#
+ a_n4516_n1000# a_4428_n1000# a_4084_n1092# a_724_n1092# a_n1964_n1092# a_1396_n1092#
+ a_n620_n1092# a_n1292_n1092# a_1740_n1000# a_1068_n1000# a_n948_n1000# a_n276_n1000#
+ a_4308_n1092# a_n4204_n1092# a_2860_n1000# a_2188_n1000# a_n3412_n1000# a_n1516_n1092#
+ a_3980_n1000# a_n1844_n1000# a_1620_n1092# a_n2636_n1092# a_n1172_n1000# a_2740_n1092#
+ a_2068_n1092# a_2412_n1000# a_396_n1000# a_n500_n1000# a_n2964_n1000# a_n3756_n1092#
+ a_n2292_n1000# a_3860_n1092# a_3188_n1092# a_n3084_n1092# a_3532_n1000# a_948_n1092#
+ a_276_n1092# a_620_n1000# a_n844_n1092# a_n3308_n1092# a_1964_n1000# a_n2516_n1000#
+ a_n172_n1092# a_1292_n1000# a_n3636_n1000# a_3412_n1092# a_n4428_n1092# a_4204_n1000#
+ a_n52_n1000# a_n4084_n1000# a_1844_n1092# a_500_n1092# a_n1068_n1092# a_n1740_n1092#
X0 a_n4308_n1000# a_n4428_n1092# a_n4516_n1000# w_n4602_n1178# pfet_06v0 ad=2.6p pd=10.52u as=4.4p ps=20.88u w=10u l=0.6u
X1 a_n2292_n1000# a_n2412_n1092# a_n2516_n1000# w_n4602_n1178# pfet_06v0 ad=2.6p pd=10.52u as=2.6p ps=10.52u w=10u l=0.6u
X2 a_n948_n1000# a_n1068_n1092# a_n1172_n1000# w_n4602_n1178# pfet_06v0 ad=2.6p pd=10.52u as=2.6p ps=10.52u w=10u l=0.6u
X3 a_n3412_n1000# a_n3532_n1092# a_n3636_n1000# w_n4602_n1178# pfet_06v0 ad=2.6p pd=10.52u as=2.6p ps=10.52u w=10u l=0.6u
X4 a_n4084_n1000# a_n4204_n1092# a_n4308_n1000# w_n4602_n1178# pfet_06v0 ad=2.6p pd=10.52u as=2.6p ps=10.52u w=10u l=0.6u
X5 a_n2068_n1000# a_n2188_n1092# a_n2292_n1000# w_n4602_n1178# pfet_06v0 ad=2.6p pd=10.52u as=2.6p ps=10.52u w=10u l=0.6u
X6 a_n724_n1000# a_n844_n1092# a_n948_n1000# w_n4602_n1178# pfet_06v0 ad=2.6p pd=10.52u as=2.6p ps=10.52u w=10u l=0.6u
X7 a_n1172_n1000# a_n1292_n1092# a_n1396_n1000# w_n4602_n1178# pfet_06v0 ad=2.6p pd=10.52u as=2.6p ps=10.52u w=10u l=0.6u
X8 a_n2964_n1000# a_n3084_n1092# a_n3188_n1000# w_n4602_n1178# pfet_06v0 ad=2.6p pd=10.52u as=2.6p ps=10.52u w=10u l=0.6u
X9 a_n276_n1000# a_n396_n1092# a_n500_n1000# w_n4602_n1178# pfet_06v0 ad=2.6p pd=10.52u as=2.6p ps=10.52u w=10u l=0.6u
X10 a_n52_n1000# a_n172_n1092# a_n276_n1000# w_n4602_n1178# pfet_06v0 ad=2.6p pd=10.52u as=2.6p ps=10.52u w=10u l=0.6u
X11 a_1964_n1000# a_1844_n1092# a_1740_n1000# w_n4602_n1178# pfet_06v0 ad=2.6p pd=10.52u as=2.6p ps=10.52u w=10u l=0.6u
X12 a_2636_n1000# a_2516_n1092# a_2412_n1000# w_n4602_n1178# pfet_06v0 ad=2.6p pd=10.52u as=2.6p ps=10.52u w=10u l=0.6u
X13 a_3084_n1000# a_2964_n1092# a_2860_n1000# w_n4602_n1178# pfet_06v0 ad=2.6p pd=10.52u as=2.6p ps=10.52u w=10u l=0.6u
X14 a_3756_n1000# a_3636_n1092# a_3532_n1000# w_n4602_n1178# pfet_06v0 ad=2.6p pd=10.52u as=2.6p ps=10.52u w=10u l=0.6u
X15 a_1740_n1000# a_1620_n1092# a_1516_n1000# w_n4602_n1178# pfet_06v0 ad=2.6p pd=10.52u as=2.6p ps=10.52u w=10u l=0.6u
X16 a_4428_n1000# a_4308_n1092# a_4204_n1000# w_n4602_n1178# pfet_06v0 ad=4.4p pd=20.88u as=2.6p ps=10.52u w=10u l=0.6u
X17 a_1068_n1000# a_948_n1092# a_844_n1000# w_n4602_n1178# pfet_06v0 ad=2.6p pd=10.52u as=2.6p ps=10.52u w=10u l=0.6u
X18 a_2860_n1000# a_2740_n1092# a_2636_n1000# w_n4602_n1178# pfet_06v0 ad=2.6p pd=10.52u as=2.6p ps=10.52u w=10u l=0.6u
X19 a_3532_n1000# a_3412_n1092# a_3308_n1000# w_n4602_n1178# pfet_06v0 ad=2.6p pd=10.52u as=2.6p ps=10.52u w=10u l=0.6u
X20 a_1516_n1000# a_1396_n1092# a_1292_n1000# w_n4602_n1178# pfet_06v0 ad=2.6p pd=10.52u as=2.6p ps=10.52u w=10u l=0.6u
X21 a_2188_n1000# a_2068_n1092# a_1964_n1000# w_n4602_n1178# pfet_06v0 ad=2.6p pd=10.52u as=2.6p ps=10.52u w=10u l=0.6u
X22 a_n1620_n1000# a_n1740_n1092# a_n1844_n1000# w_n4602_n1178# pfet_06v0 ad=2.6p pd=10.52u as=2.6p ps=10.52u w=10u l=0.6u
X23 a_3980_n1000# a_3860_n1092# a_3756_n1000# w_n4602_n1178# pfet_06v0 ad=2.6p pd=10.52u as=2.6p ps=10.52u w=10u l=0.6u
X24 a_172_n1000# a_52_n1092# a_n52_n1000# w_n4602_n1178# pfet_06v0 ad=2.6p pd=10.52u as=2.6p ps=10.52u w=10u l=0.6u
X25 a_n2740_n1000# a_n2860_n1092# a_n2964_n1000# w_n4602_n1178# pfet_06v0 ad=2.6p pd=10.52u as=2.6p ps=10.52u w=10u l=0.6u
X26 a_844_n1000# a_724_n1092# a_620_n1000# w_n4602_n1178# pfet_06v0 ad=2.6p pd=10.52u as=2.6p ps=10.52u w=10u l=0.6u
X27 a_1292_n1000# a_1172_n1092# a_1068_n1000# w_n4602_n1178# pfet_06v0 ad=2.6p pd=10.52u as=2.6p ps=10.52u w=10u l=0.6u
X28 a_3308_n1000# a_3188_n1092# a_3084_n1000# w_n4602_n1178# pfet_06v0 ad=2.6p pd=10.52u as=2.6p ps=10.52u w=10u l=0.6u
X29 a_n1396_n1000# a_n1516_n1092# a_n1620_n1000# w_n4602_n1178# pfet_06v0 ad=2.6p pd=10.52u as=2.6p ps=10.52u w=10u l=0.6u
X30 a_2412_n1000# a_2292_n1092# a_2188_n1000# w_n4602_n1178# pfet_06v0 ad=2.6p pd=10.52u as=2.6p ps=10.52u w=10u l=0.6u
X31 a_n3860_n1000# a_n3980_n1092# a_n4084_n1000# w_n4602_n1178# pfet_06v0 ad=2.6p pd=10.52u as=2.6p ps=10.52u w=10u l=0.6u
X32 a_n1844_n1000# a_n1964_n1092# a_n2068_n1000# w_n4602_n1178# pfet_06v0 ad=2.6p pd=10.52u as=2.6p ps=10.52u w=10u l=0.6u
X33 a_620_n1000# a_500_n1092# a_396_n1000# w_n4602_n1178# pfet_06v0 ad=2.6p pd=10.52u as=2.6p ps=10.52u w=10u l=0.6u
X34 a_n2516_n1000# a_n2636_n1092# a_n2740_n1000# w_n4602_n1178# pfet_06v0 ad=2.6p pd=10.52u as=2.6p ps=10.52u w=10u l=0.6u
X35 a_n3188_n1000# a_n3308_n1092# a_n3412_n1000# w_n4602_n1178# pfet_06v0 ad=2.6p pd=10.52u as=2.6p ps=10.52u w=10u l=0.6u
X36 a_n500_n1000# a_n620_n1092# a_n724_n1000# w_n4602_n1178# pfet_06v0 ad=2.6p pd=10.52u as=2.6p ps=10.52u w=10u l=0.6u
X37 a_4204_n1000# a_4084_n1092# a_3980_n1000# w_n4602_n1178# pfet_06v0 ad=2.6p pd=10.52u as=2.6p ps=10.52u w=10u l=0.6u
X38 a_n3636_n1000# a_n3756_n1092# a_n3860_n1000# w_n4602_n1178# pfet_06v0 ad=2.6p pd=10.52u as=2.6p ps=10.52u w=10u l=0.6u
X39 a_396_n1000# a_276_n1092# a_172_n1000# w_n4602_n1178# pfet_06v0 ad=2.6p pd=10.52u as=2.6p ps=10.52u w=10u l=0.6u
.ends

.subckt nfet_05v0_5HT2VB a_3980_n500# a_n52_n500# a_3412_n592# a_2068_n592# a_2636_n500#
+ a_172_n500# a_n500_n500# a_3860_n592# a_4204_n500# a_4084_n592# a_2516_n592# a_n396_n592#
+ a_n1292_n592# a_620_n500# a_n4308_n500# a_52_n592# a_2964_n592# a_3308_n500# a_3188_n592#
+ a_500_n592# a_n1740_n592# a_n844_n592# a_3756_n500# a_n276_n500# a_n1172_n500# a_3636_n592#
+ a_396_n500# a_n724_n500# a_n1620_n500# a_n1068_n592# a_n2412_n592# a_4428_n500#
+ a_n4516_n500# a_276_n592# a_n2860_n592# a_844_n500# a_n2292_n500# a_4308_n592# a_n1516_n592#
+ a_n3084_n592# a_724_n592# a_1292_n500# a_n1964_n592# a_n1396_n500# a_n2740_n500#
+ a_n2188_n592# a_n3532_n592# a_1172_n592# a_1740_n500# a_n3980_n592# a_n2636_n592#
+ a_n948_n500# a_n1844_n500# a_1620_n592# a_n4204_n592# a_n2068_n500# a_n3412_n500#
+ a_2412_n500# a_1068_n500# a_n3860_n500# a_2292_n592# a_n2516_n500# a_n4084_n500#
+ a_948_n592# a_n3308_n592# a_2860_n500# a_n172_n592# a_3084_n500# a_1516_n500# a_n2964_n500#
+ a_2740_n592# a_1396_n592# a_n3756_n592# a_n3188_n500# a_1964_n500# a_n620_n592#
+ a_3532_n500# a_2188_n500# a_n3636_n500# a_1844_n592# a_n4428_n592# VSUBS
X0 a_3084_n500# a_2964_n592# a_2860_n500# VSUBS nfet_05v0 ad=1.3p pd=5.52u as=1.3p ps=5.52u w=5u l=0.6u
X1 a_1740_n500# a_1620_n592# a_1516_n500# VSUBS nfet_05v0 ad=1.3p pd=5.52u as=1.3p ps=5.52u w=5u l=0.6u
X2 a_3756_n500# a_3636_n592# a_3532_n500# VSUBS nfet_05v0 ad=1.3p pd=5.52u as=1.3p ps=5.52u w=5u l=0.6u
X3 a_4428_n500# a_4308_n592# a_4204_n500# VSUBS nfet_05v0 ad=2.2p pd=10.88u as=1.3p ps=5.52u w=5u l=0.6u
X4 a_2860_n500# a_2740_n592# a_2636_n500# VSUBS nfet_05v0 ad=1.3p pd=5.52u as=1.3p ps=5.52u w=5u l=0.6u
X5 a_1068_n500# a_948_n592# a_844_n500# VSUBS nfet_05v0 ad=1.3p pd=5.52u as=1.3p ps=5.52u w=5u l=0.6u
X6 a_1516_n500# a_1396_n592# a_1292_n500# VSUBS nfet_05v0 ad=1.3p pd=5.52u as=1.3p ps=5.52u w=5u l=0.6u
X7 a_3532_n500# a_3412_n592# a_3308_n500# VSUBS nfet_05v0 ad=1.3p pd=5.52u as=1.3p ps=5.52u w=5u l=0.6u
X8 a_2188_n500# a_2068_n592# a_1964_n500# VSUBS nfet_05v0 ad=1.3p pd=5.52u as=1.3p ps=5.52u w=5u l=0.6u
X9 a_n1620_n500# a_n1740_n592# a_n1844_n500# VSUBS nfet_05v0 ad=1.3p pd=5.52u as=1.3p ps=5.52u w=5u l=0.6u
X10 a_3980_n500# a_3860_n592# a_3756_n500# VSUBS nfet_05v0 ad=1.3p pd=5.52u as=1.3p ps=5.52u w=5u l=0.6u
X11 a_172_n500# a_52_n592# a_n52_n500# VSUBS nfet_05v0 ad=1.3p pd=5.52u as=1.3p ps=5.52u w=5u l=0.6u
X12 a_844_n500# a_724_n592# a_620_n500# VSUBS nfet_05v0 ad=1.3p pd=5.52u as=1.3p ps=5.52u w=5u l=0.6u
X13 a_3308_n500# a_3188_n592# a_3084_n500# VSUBS nfet_05v0 ad=1.3p pd=5.52u as=1.3p ps=5.52u w=5u l=0.6u
X14 a_n2740_n500# a_n2860_n592# a_n2964_n500# VSUBS nfet_05v0 ad=1.3p pd=5.52u as=1.3p ps=5.52u w=5u l=0.6u
X15 a_1292_n500# a_1172_n592# a_1068_n500# VSUBS nfet_05v0 ad=1.3p pd=5.52u as=1.3p ps=5.52u w=5u l=0.6u
X16 a_n1396_n500# a_n1516_n592# a_n1620_n500# VSUBS nfet_05v0 ad=1.3p pd=5.52u as=1.3p ps=5.52u w=5u l=0.6u
X17 a_n3860_n500# a_n3980_n592# a_n4084_n500# VSUBS nfet_05v0 ad=1.3p pd=5.52u as=1.3p ps=5.52u w=5u l=0.6u
X18 a_2412_n500# a_2292_n592# a_2188_n500# VSUBS nfet_05v0 ad=1.3p pd=5.52u as=1.3p ps=5.52u w=5u l=0.6u
X19 a_n1844_n500# a_n1964_n592# a_n2068_n500# VSUBS nfet_05v0 ad=1.3p pd=5.52u as=1.3p ps=5.52u w=5u l=0.6u
X20 a_620_n500# a_500_n592# a_396_n500# VSUBS nfet_05v0 ad=1.3p pd=5.52u as=1.3p ps=5.52u w=5u l=0.6u
X21 a_n3188_n500# a_n3308_n592# a_n3412_n500# VSUBS nfet_05v0 ad=1.3p pd=5.52u as=1.3p ps=5.52u w=5u l=0.6u
X22 a_n2516_n500# a_n2636_n592# a_n2740_n500# VSUBS nfet_05v0 ad=1.3p pd=5.52u as=1.3p ps=5.52u w=5u l=0.6u
X23 a_n500_n500# a_n620_n592# a_n724_n500# VSUBS nfet_05v0 ad=1.3p pd=5.52u as=1.3p ps=5.52u w=5u l=0.6u
X24 a_4204_n500# a_4084_n592# a_3980_n500# VSUBS nfet_05v0 ad=1.3p pd=5.52u as=1.3p ps=5.52u w=5u l=0.6u
X25 a_n4308_n500# a_n4428_n592# a_n4516_n500# VSUBS nfet_05v0 ad=1.3p pd=5.52u as=2.2p ps=10.88u w=5u l=0.6u
X26 a_n3636_n500# a_n3756_n592# a_n3860_n500# VSUBS nfet_05v0 ad=1.3p pd=5.52u as=1.3p ps=5.52u w=5u l=0.6u
X27 a_396_n500# a_276_n592# a_172_n500# VSUBS nfet_05v0 ad=1.3p pd=5.52u as=1.3p ps=5.52u w=5u l=0.6u
X28 a_n2292_n500# a_n2412_n592# a_n2516_n500# VSUBS nfet_05v0 ad=1.3p pd=5.52u as=1.3p ps=5.52u w=5u l=0.6u
X29 a_n948_n500# a_n1068_n592# a_n1172_n500# VSUBS nfet_05v0 ad=1.3p pd=5.52u as=1.3p ps=5.52u w=5u l=0.6u
X30 a_n3412_n500# a_n3532_n592# a_n3636_n500# VSUBS nfet_05v0 ad=1.3p pd=5.52u as=1.3p ps=5.52u w=5u l=0.6u
X31 a_n4084_n500# a_n4204_n592# a_n4308_n500# VSUBS nfet_05v0 ad=1.3p pd=5.52u as=1.3p ps=5.52u w=5u l=0.6u
X32 a_n2068_n500# a_n2188_n592# a_n2292_n500# VSUBS nfet_05v0 ad=1.3p pd=5.52u as=1.3p ps=5.52u w=5u l=0.6u
X33 a_n724_n500# a_n844_n592# a_n948_n500# VSUBS nfet_05v0 ad=1.3p pd=5.52u as=1.3p ps=5.52u w=5u l=0.6u
X34 a_n1172_n500# a_n1292_n592# a_n1396_n500# VSUBS nfet_05v0 ad=1.3p pd=5.52u as=1.3p ps=5.52u w=5u l=0.6u
X35 a_n2964_n500# a_n3084_n592# a_n3188_n500# VSUBS nfet_05v0 ad=1.3p pd=5.52u as=1.3p ps=5.52u w=5u l=0.6u
X36 a_n276_n500# a_n396_n592# a_n500_n500# VSUBS nfet_05v0 ad=1.3p pd=5.52u as=1.3p ps=5.52u w=5u l=0.6u
X37 a_n52_n500# a_n172_n592# a_n276_n500# VSUBS nfet_05v0 ad=1.3p pd=5.52u as=1.3p ps=5.52u w=5u l=0.6u
X38 a_1964_n500# a_1844_n592# a_1740_n500# VSUBS nfet_05v0 ad=1.3p pd=5.52u as=1.3p ps=5.52u w=5u l=0.6u
X39 a_2636_n500# a_2516_n592# a_2412_n500# VSUBS nfet_05v0 ad=1.3p pd=5.52u as=1.3p ps=5.52u w=5u l=0.6u
.ends

.subckt pfet_05v0_KB9L9L a_52_n118# a_n152_n118# a_152_n26# a_n240_n26# a_n52_n26#
+ w_n326_n204#
X0 a_152_n26# a_52_n118# a_n52_n26# w_n326_n204# pfet_05v0 ad=0.22p pd=1.88u as=0.13p ps=1.02u w=0.5u l=0.5u
X1 a_n52_n26# a_n152_n118# a_n240_n26# w_n326_n204# pfet_05v0 ad=0.13p pd=1.02u as=0.22p ps=1.88u w=0.5u l=0.5u
.ends

.subckt gate_drive_med in_p in_n vdd out outn vss
Xnfet_05v0_C5JAWQ_0 vss in_p vss m1_n710_2205# m3_n876_2034# in_n vss nfet_05v0_C5JAWQ
Xpfet_06v0_2T3SUY_0 out outn outn vdd outn m3_310_506# m3_n171_480# vdd outn m3_n171_480#
+ m3_n171_480# out m3_310_506# vdd m3_310_506# vdd outn outn m3_310_506# outn outn
+ outn m3_n171_480# out vdd vdd vdd m3_310_506# vdd vdd outn m3_310_506# m3_310_506#
+ outn m3_310_506# m3_310_506# vdd out vdd outn outn m3_n876_2034# out vdd m3_310_506#
+ m3_310_506# vdd vdd outn m3_310_506# outn outn outn out vdd vdd m3_310_506# m3_n171_480#
+ vdd outn outn m3_n171_480# vdd outn m3_310_506# outn m3_310_506# m3_n171_480# out
+ outn m3_310_506# vdd vdd outn m3_n876_2034# out vdd vdd outn m3_310_506# m3_310_506#
+ m3_310_506# pfet_06v0_2T3SUY
Xnfet_05v0_5HT2VB_0 vss vss outn outn vss outn vss outn out outn outn m3_310_506#
+ m3_310_506# outn m3_n171_480# m3_310_506# outn out outn m3_310_506# m3_310_506#
+ m3_310_506# out outn outn outn vss outn outn m3_310_506# m3_310_506# vss vss m3_310_506#
+ m3_n171_480# vss vss outn m3_310_506# m3_n171_480# m3_310_506# vss m3_310_506# vss
+ vss m3_310_506# m3_n171_480# outn vss m3_n171_480# m3_310_506# vss vss outn m3_n876_2034#
+ outn m3_310_506# out out m3_310_506# outn outn vss outn m3_n171_480# out m3_310_506#
+ vss out m3_310_506# outn outn m3_n171_480# vss out m3_310_506# vss vss vss outn
+ m3_n876_2034# vss nfet_05v0_5HT2VB
Xpfet_05v0_KB9L9L_0 m1_n710_2205# m3_n876_2034# m3_n876_2034# m1_n710_2205# vdd vdd
+ pfet_05v0_KB9L9L
.ends

.subckt analog_switch_med in out dvdd dvss avss enable avdd
Xgf180mcu_as_sc_mcu7t3v3__fillcap_4_0 dvdd dvdd dvss dvss gf180mcu_as_sc_mcu7t3v3__fillcap_4
Xgf180mcu_as_sc_mcu7t3v3__inv_4_0 dvdd dvdd dvss dvss gate_drive_med_0/in_n enable
+ gf180mcu_as_sc_mcu7t3v3__inv_4
Xgf180mcu_as_sc_mcu7t3v3__fillcap_4_1 dvdd dvdd dvss dvss gf180mcu_as_sc_mcu7t3v3__fillcap_4
Xgf180mcu_as_sc_mcu7t3v3__inv_4_1 dvdd dvdd dvss dvss gate_drive_med_0/in_p gate_drive_med_0/in_n
+ gf180mcu_as_sc_mcu7t3v3__inv_4
Xpfet_05v0_6SLWPD_0 out gate_drive_med_0/outn in out in gate_drive_med_0/outn out
+ gate_drive_med_0/outn gate_drive_med_0/outn gate_drive_med_0/outn in gate_drive_med_0/outn
+ gate_drive_med_0/outn gate_drive_med_0/outn in out out gate_drive_med_0/outn out
+ in out in in out gate_drive_med_0/outn in gate_drive_med_0/outn gate_drive_med_0/outn
+ in out gate_drive_med_0/outn out gate_drive_med_0/outn gate_drive_med_0/outn out
+ gate_drive_med_0/outn out gate_drive_med_0/outn out in in gate_drive_med_0/outn
+ gate_drive_med_0/outn gate_drive_med_0/outn gate_drive_med_0/outn in gate_drive_med_0/outn
+ gate_drive_med_0/outn out in out in gate_drive_med_0/outn out out gate_drive_med_0/outn
+ gate_drive_med_0/outn in gate_drive_med_0/outn out in in gate_drive_med_0/outn gate_drive_med_0/outn
+ gate_drive_med_0/outn gate_drive_med_0/outn avdd gate_drive_med_0/outn out out gate_drive_med_0/outn
+ in gate_drive_med_0/outn in gate_drive_med_0/outn in gate_drive_med_0/outn in gate_drive_med_0/outn
+ out gate_drive_med_0/outn gate_drive_med_0/outn pfet_05v0_6SLWPD
Xgf180mcu_as_sc_mcu7t3v3__diode_2_0 dvdd dvdd dvss dvss enable gf180mcu_as_sc_mcu7t3v3__diode_2
Xnfet_05v0_VPM4SY_0 in gate_drive_med_0/out gate_drive_med_0/out out in in out out
+ in in gate_drive_med_0/out gate_drive_med_0/out in gate_drive_med_0/out out in gate_drive_med_0/out
+ avss out in in gate_drive_med_0/out gate_drive_med_0/out gate_drive_med_0/out in
+ gate_drive_med_0/out gate_drive_med_0/out out gate_drive_med_0/out gate_drive_med_0/out
+ out in gate_drive_med_0/out out out gate_drive_med_0/out out in gate_drive_med_0/out
+ gate_drive_med_0/out gate_drive_med_0/out gate_drive_med_0/out out gate_drive_med_0/out
+ gate_drive_med_0/out out gate_drive_med_0/out gate_drive_med_0/out in out out out
+ gate_drive_med_0/out out gate_drive_med_0/out gate_drive_med_0/out out in in in
+ gate_drive_med_0/out out out gate_drive_med_0/out in gate_drive_med_0/out in gate_drive_med_0/out
+ out gate_drive_med_0/out in gate_drive_med_0/out gate_drive_med_0/out in gate_drive_med_0/out
+ in gate_drive_med_0/out gate_drive_med_0/out gate_drive_med_0/out gate_drive_med_0/out
+ gate_drive_med_0/out out nfet_05v0_VPM4SY
Xgate_drive_med_0 gate_drive_med_0/in_p gate_drive_med_0/in_n avdd gate_drive_med_0/out
+ gate_drive_med_0/outn avss gate_drive_med
.ends
