* NGSPICE file created from power_stage3v3.ext - technology: gf180mcuD

.subckt pfet_03v3_GVZKMY a_n132_2168# a_348_56# a_n36_n8484# a_988_n2056# a_n132_6392#
+ a_n612_n2056# a_988_n6280# a_n932_2168# a_n132_n2056# a_n612_n6280# a_n1076_n4069#
+ a_828_n4168# a_n772_56# a_n132_n6280# a_n932_6392# a_348_n4168# a_n1076_n8293# a_828_n8392#
+ a_n1076_4379# a_n516_n8484# a_508_4280# a_348_n8392# a_668_2168# a_n132_4280# a_668_6392#
+ a_188_56# a_n612_56# a_828_n2056# a_n292_2168# a_n932_4280# a_n1076_2267# a_348_n2056#
+ a_n1076_n6181# a_828_n6280# a_n292_6392# a_348_n6280# a_n1076_6491# a_n1076_155#
+ a_924_n8484# a_444_n8484# a_668_4280# a_n932_n4168# a_n996_n8484# a_n292_4280# a_n452_n4168#
+ a_n932_n8392# a_n452_56# a_n452_n8392# a_828_2168# a_28_2168# a_828_6392# a_28_n4168#
+ a_28_6392# a_28_n8392# a_n452_2168# a_n452_6392# a_n932_n2056# a_988_56# a_n932_n6280#
+ a_n452_n2056# a_n452_n6280# a_668_n4168# a_n1076_n1957# a_188_n4168# a_668_n8392#
+ a_n836_n8484# a_828_4280# a_188_2168# a_28_4280# a_n292_56# a_28_n2056# a_188_n8392#
+ a_n356_n8484# a_188_6392# a_28_n6280# w_n1238_n8602# a_988_2168# a_n452_4280# a_828_56#
+ a_988_6392# a_668_n2056# a_n132_56# a_188_n2056# a_668_n6280# a_188_n6280# a_188_4280#
+ a_n612_2168# a_508_n4168# a_508_n8392# a_n612_6392# a_764_n8484# a_988_4280# a_284_n8484#
+ a_348_2168# a_668_56# a_348_6392# a_n772_n4168# a_n292_n4168# a_n772_n8392# a_508_n2056#
+ a_n292_n8392# a_n612_4280# a_28_56# a_508_n6280# a_n772_2168# a_n772_6392# a_508_56#
+ a_604_n8484# a_124_n8484# a_348_4280# a_n772_n2056# a_n292_n2056# a_n772_n6280#
+ a_988_n4168# a_n932_56# a_n292_n6280# a_988_n8392# a_n612_n4168# a_n676_n8484# a_n132_n4168#
+ a_n612_n8392# a_n196_n8484# a_n132_n8392# a_508_2168# a_n772_4280# a_508_6392#
X0 a_n772_6392# a_n836_n8484# a_n932_6392# w_n1238_n8602# pfet_03v3 ad=2.6p pd=10.52u as=2.6p ps=10.52u w=10u l=0.28u
X1 a_n452_n6280# a_n516_n8484# a_n612_n6280# w_n1238_n8602# pfet_03v3 ad=2.6p pd=10.52u as=2.6p ps=10.52u w=10u l=0.28u
X2 a_n452_n4168# a_n516_n8484# a_n612_n4168# w_n1238_n8602# pfet_03v3 ad=2.6p pd=10.52u as=2.6p ps=10.52u w=10u l=0.28u
X3 a_n612_2168# a_n676_n8484# a_n772_2168# w_n1238_n8602# pfet_03v3 ad=2.6p pd=10.52u as=2.6p ps=10.52u w=10u l=0.28u
X4 a_n772_4280# a_n836_n8484# a_n932_4280# w_n1238_n8602# pfet_03v3 ad=2.6p pd=10.52u as=2.6p ps=10.52u w=10u l=0.28u
X5 a_n452_n2056# a_n516_n8484# a_n612_n2056# w_n1238_n8602# pfet_03v3 ad=2.6p pd=10.52u as=2.6p ps=10.52u w=10u l=0.28u
X6 a_n452_2168# a_n516_n8484# a_n612_2168# w_n1238_n8602# pfet_03v3 ad=2.6p pd=10.52u as=2.6p ps=10.52u w=10u l=0.28u
X7 a_828_6392# a_764_n8484# a_668_6392# w_n1238_n8602# pfet_03v3 ad=2.6p pd=10.52u as=2.6p ps=10.52u w=10u l=0.28u
X8 a_n452_56# a_n516_n8484# a_n612_56# w_n1238_n8602# pfet_03v3 ad=2.6p pd=10.52u as=2.6p ps=10.52u w=10u l=0.28u
X9 a_828_4280# a_764_n8484# a_668_4280# w_n1238_n8602# pfet_03v3 ad=2.6p pd=10.52u as=2.6p ps=10.52u w=10u l=0.28u
X10 a_348_56# a_284_n8484# a_188_56# w_n1238_n8602# pfet_03v3 ad=2.6p pd=10.52u as=2.6p ps=10.52u w=10u l=0.28u
X11 a_188_n6280# a_124_n8484# a_28_n6280# w_n1238_n8602# pfet_03v3 ad=2.6p pd=10.52u as=2.6p ps=10.52u w=10u l=0.28u
X12 a_188_n4168# a_124_n8484# a_28_n4168# w_n1238_n8602# pfet_03v3 ad=2.6p pd=10.52u as=2.6p ps=10.52u w=10u l=0.28u
X13 a_188_n2056# a_124_n8484# a_28_n2056# w_n1238_n8602# pfet_03v3 ad=2.6p pd=10.52u as=2.6p ps=10.52u w=10u l=0.28u
X14 a_668_6392# a_604_n8484# a_508_6392# w_n1238_n8602# pfet_03v3 ad=2.6p pd=10.52u as=2.6p ps=10.52u w=10u l=0.28u
X15 a_508_2168# a_444_n8484# a_348_2168# w_n1238_n8602# pfet_03v3 ad=2.6p pd=10.52u as=2.6p ps=10.52u w=10u l=0.28u
X16 a_668_4280# a_604_n8484# a_508_4280# w_n1238_n8602# pfet_03v3 ad=2.6p pd=10.52u as=2.6p ps=10.52u w=10u l=0.28u
X17 a_668_n6280# a_604_n8484# a_508_n6280# w_n1238_n8602# pfet_03v3 ad=2.6p pd=10.52u as=2.6p ps=10.52u w=10u l=0.28u
X18 a_668_n4168# a_604_n8484# a_508_n4168# w_n1238_n8602# pfet_03v3 ad=2.6p pd=10.52u as=2.6p ps=10.52u w=10u l=0.28u
X19 a_668_n2056# a_604_n8484# a_508_n2056# w_n1238_n8602# pfet_03v3 ad=2.6p pd=10.52u as=2.6p ps=10.52u w=10u l=0.28u
X20 a_n292_n6280# a_n356_n8484# a_n452_n6280# w_n1238_n8602# pfet_03v3 ad=2.6p pd=10.52u as=2.6p ps=10.52u w=10u l=0.28u
X21 a_n292_n4168# a_n356_n8484# a_n452_n4168# w_n1238_n8602# pfet_03v3 ad=2.6p pd=10.52u as=2.6p ps=10.52u w=10u l=0.28u
X22 a_n292_n2056# a_n356_n8484# a_n452_n2056# w_n1238_n8602# pfet_03v3 ad=2.6p pd=10.52u as=2.6p ps=10.52u w=10u l=0.28u
X23 a_n772_n6280# a_n836_n8484# a_n932_n6280# w_n1238_n8602# pfet_03v3 ad=2.6p pd=10.52u as=2.6p ps=10.52u w=10u l=0.28u
X24 a_28_n6280# a_n36_n8484# a_n132_n6280# w_n1238_n8602# pfet_03v3 ad=2.6p pd=10.52u as=2.6p ps=10.52u w=10u l=0.28u
X25 a_n772_n4168# a_n836_n8484# a_n932_n4168# w_n1238_n8602# pfet_03v3 ad=2.6p pd=10.52u as=2.6p ps=10.52u w=10u l=0.28u
X26 a_28_n4168# a_n36_n8484# a_n132_n4168# w_n1238_n8602# pfet_03v3 ad=2.6p pd=10.52u as=2.6p ps=10.52u w=10u l=0.28u
X27 a_n772_n2056# a_n836_n8484# a_n932_n2056# w_n1238_n8602# pfet_03v3 ad=2.6p pd=10.52u as=2.6p ps=10.52u w=10u l=0.28u
X28 a_28_n2056# a_n36_n8484# a_n132_n2056# w_n1238_n8602# pfet_03v3 ad=2.6p pd=10.52u as=2.6p ps=10.52u w=10u l=0.28u
X29 a_988_56# a_924_n8484# a_828_56# w_n1238_n8602# pfet_03v3 ad=4.33565p pd=20.88u as=2.6p ps=10.52u w=10u l=0.28u
X30 a_n612_6392# a_n676_n8484# a_n772_6392# w_n1238_n8602# pfet_03v3 ad=2.6p pd=10.52u as=2.6p ps=10.52u w=10u l=0.28u
X31 a_n452_n8392# a_n516_n8484# a_n612_n8392# w_n1238_n8602# pfet_03v3 ad=2.6p pd=10.52u as=2.6p ps=10.52u w=10u l=0.28u
X32 a_n612_4280# a_n676_n8484# a_n772_4280# w_n1238_n8602# pfet_03v3 ad=2.6p pd=10.52u as=2.6p ps=10.52u w=10u l=0.28u
X33 a_188_56# a_124_n8484# a_28_56# w_n1238_n8602# pfet_03v3 ad=2.6p pd=10.52u as=2.6p ps=10.52u w=10u l=0.28u
X34 a_n452_6392# a_n516_n8484# a_n612_6392# w_n1238_n8602# pfet_03v3 ad=2.6p pd=10.52u as=2.6p ps=10.52u w=10u l=0.28u
X35 a_n292_2168# a_n356_n8484# a_n452_2168# w_n1238_n8602# pfet_03v3 ad=2.6p pd=10.52u as=2.6p ps=10.52u w=10u l=0.28u
X36 a_n452_4280# a_n516_n8484# a_n612_4280# w_n1238_n8602# pfet_03v3 ad=2.6p pd=10.52u as=2.6p ps=10.52u w=10u l=0.28u
X37 a_n292_56# a_n356_n8484# a_n452_56# w_n1238_n8602# pfet_03v3 ad=2.6p pd=10.52u as=2.6p ps=10.52u w=10u l=0.28u
X38 a_508_n6280# a_444_n8484# a_348_n6280# w_n1238_n8602# pfet_03v3 ad=2.6p pd=10.52u as=2.6p ps=10.52u w=10u l=0.28u
X39 a_508_n4168# a_444_n8484# a_348_n4168# w_n1238_n8602# pfet_03v3 ad=2.6p pd=10.52u as=2.6p ps=10.52u w=10u l=0.28u
X40 a_508_n2056# a_444_n8484# a_348_n2056# w_n1238_n8602# pfet_03v3 ad=2.6p pd=10.52u as=2.6p ps=10.52u w=10u l=0.28u
X41 a_988_n6280# a_924_n8484# a_828_n6280# w_n1238_n8602# pfet_03v3 ad=4.33565p pd=20.88u as=2.6p ps=10.52u w=10u l=0.28u
X42 a_988_n4168# a_924_n8484# a_828_n4168# w_n1238_n8602# pfet_03v3 ad=4.33565p pd=20.88u as=2.6p ps=10.52u w=10u l=0.28u
X43 a_n132_n6280# a_n196_n8484# a_n292_n6280# w_n1238_n8602# pfet_03v3 ad=2.6p pd=10.52u as=2.6p ps=10.52u w=10u l=0.28u
X44 a_n132_n4168# a_n196_n8484# a_n292_n4168# w_n1238_n8602# pfet_03v3 ad=2.6p pd=10.52u as=2.6p ps=10.52u w=10u l=0.28u
X45 a_988_n2056# a_924_n8484# a_828_n2056# w_n1238_n8602# pfet_03v3 ad=4.33565p pd=20.88u as=2.6p ps=10.52u w=10u l=0.28u
X46 a_188_n8392# a_124_n8484# a_28_n8392# w_n1238_n8602# pfet_03v3 ad=2.6p pd=10.52u as=2.6p ps=10.52u w=10u l=0.28u
X47 a_n132_n2056# a_n196_n8484# a_n292_n2056# w_n1238_n8602# pfet_03v3 ad=2.6p pd=10.52u as=2.6p ps=10.52u w=10u l=0.28u
X48 a_508_6392# a_444_n8484# a_348_6392# w_n1238_n8602# pfet_03v3 ad=2.6p pd=10.52u as=2.6p ps=10.52u w=10u l=0.28u
X49 a_n612_n6280# a_n676_n8484# a_n772_n6280# w_n1238_n8602# pfet_03v3 ad=2.6p pd=10.52u as=2.6p ps=10.52u w=10u l=0.28u
X50 a_n612_n4168# a_n676_n8484# a_n772_n4168# w_n1238_n8602# pfet_03v3 ad=2.6p pd=10.52u as=2.6p ps=10.52u w=10u l=0.28u
X51 a_348_2168# a_284_n8484# a_188_2168# w_n1238_n8602# pfet_03v3 ad=2.6p pd=10.52u as=2.6p ps=10.52u w=10u l=0.28u
X52 a_508_4280# a_444_n8484# a_348_4280# w_n1238_n8602# pfet_03v3 ad=2.6p pd=10.52u as=2.6p ps=10.52u w=10u l=0.28u
X53 a_668_n8392# a_604_n8484# a_508_n8392# w_n1238_n8602# pfet_03v3 ad=2.6p pd=10.52u as=2.6p ps=10.52u w=10u l=0.28u
X54 a_n612_n2056# a_n676_n8484# a_n772_n2056# w_n1238_n8602# pfet_03v3 ad=2.6p pd=10.52u as=2.6p ps=10.52u w=10u l=0.28u
X55 a_28_2168# a_n36_n8484# a_n132_2168# w_n1238_n8602# pfet_03v3 ad=2.6p pd=10.52u as=2.6p ps=10.52u w=10u l=0.28u
X56 a_188_2168# a_124_n8484# a_28_2168# w_n1238_n8602# pfet_03v3 ad=2.6p pd=10.52u as=2.6p ps=10.52u w=10u l=0.28u
X57 a_n292_n8392# a_n356_n8484# a_n452_n8392# w_n1238_n8602# pfet_03v3 ad=2.6p pd=10.52u as=2.6p ps=10.52u w=10u l=0.28u
X58 a_828_56# a_764_n8484# a_668_56# w_n1238_n8602# pfet_03v3 ad=2.6p pd=10.52u as=2.6p ps=10.52u w=10u l=0.28u
X59 a_n932_56# a_n996_n8484# a_n1076_155# w_n1238_n8602# pfet_03v3 ad=2.6p pd=10.52u as=4.33565p ps=20.88u w=10u l=0.28u
X60 a_n772_n8392# a_n836_n8484# a_n932_n8392# w_n1238_n8602# pfet_03v3 ad=2.6p pd=10.52u as=2.6p ps=10.52u w=10u l=0.28u
X61 a_28_n8392# a_n36_n8484# a_n132_n8392# w_n1238_n8602# pfet_03v3 ad=2.6p pd=10.52u as=2.6p ps=10.52u w=10u l=0.28u
X62 a_988_2168# a_924_n8484# a_828_2168# w_n1238_n8602# pfet_03v3 ad=4.33565p pd=20.88u as=2.6p ps=10.52u w=10u l=0.28u
X63 a_n132_56# a_n196_n8484# a_n292_56# w_n1238_n8602# pfet_03v3 ad=2.6p pd=10.52u as=2.6p ps=10.52u w=10u l=0.28u
X64 a_348_n6280# a_284_n8484# a_188_n6280# w_n1238_n8602# pfet_03v3 ad=2.6p pd=10.52u as=2.6p ps=10.52u w=10u l=0.28u
X65 a_348_n4168# a_284_n8484# a_188_n4168# w_n1238_n8602# pfet_03v3 ad=2.6p pd=10.52u as=2.6p ps=10.52u w=10u l=0.28u
X66 a_348_n2056# a_284_n8484# a_188_n2056# w_n1238_n8602# pfet_03v3 ad=2.6p pd=10.52u as=2.6p ps=10.52u w=10u l=0.28u
X67 a_n292_6392# a_n356_n8484# a_n452_6392# w_n1238_n8602# pfet_03v3 ad=2.6p pd=10.52u as=2.6p ps=10.52u w=10u l=0.28u
X68 a_828_n6280# a_764_n8484# a_668_n6280# w_n1238_n8602# pfet_03v3 ad=2.6p pd=10.52u as=2.6p ps=10.52u w=10u l=0.28u
X69 a_n132_2168# a_n196_n8484# a_n292_2168# w_n1238_n8602# pfet_03v3 ad=2.6p pd=10.52u as=2.6p ps=10.52u w=10u l=0.28u
X70 a_828_n4168# a_764_n8484# a_668_n4168# w_n1238_n8602# pfet_03v3 ad=2.6p pd=10.52u as=2.6p ps=10.52u w=10u l=0.28u
X71 a_n292_4280# a_n356_n8484# a_n452_4280# w_n1238_n8602# pfet_03v3 ad=2.6p pd=10.52u as=2.6p ps=10.52u w=10u l=0.28u
X72 a_828_n2056# a_764_n8484# a_668_n2056# w_n1238_n8602# pfet_03v3 ad=2.6p pd=10.52u as=2.6p ps=10.52u w=10u l=0.28u
X73 a_508_n8392# a_444_n8484# a_348_n8392# w_n1238_n8602# pfet_03v3 ad=2.6p pd=10.52u as=2.6p ps=10.52u w=10u l=0.28u
X74 a_n932_2168# a_n996_n8484# a_n1076_2267# w_n1238_n8602# pfet_03v3 ad=2.6p pd=10.52u as=4.33565p ps=20.88u w=10u l=0.28u
X75 a_n932_n6280# a_n996_n8484# a_n1076_n6181# w_n1238_n8602# pfet_03v3 ad=2.6p pd=10.52u as=4.33565p ps=20.88u w=10u l=0.28u
X76 a_668_56# a_604_n8484# a_508_56# w_n1238_n8602# pfet_03v3 ad=2.6p pd=10.52u as=2.6p ps=10.52u w=10u l=0.28u
X77 a_n932_n4168# a_n996_n8484# a_n1076_n4069# w_n1238_n8602# pfet_03v3 ad=2.6p pd=10.52u as=4.33565p ps=20.88u w=10u l=0.28u
X78 a_988_n8392# a_924_n8484# a_828_n8392# w_n1238_n8602# pfet_03v3 ad=4.33565p pd=20.88u as=2.6p ps=10.52u w=10u l=0.28u
X79 a_n932_n2056# a_n996_n8484# a_n1076_n1957# w_n1238_n8602# pfet_03v3 ad=2.6p pd=10.52u as=4.33565p ps=20.88u w=10u l=0.28u
X80 a_n132_n8392# a_n196_n8484# a_n292_n8392# w_n1238_n8602# pfet_03v3 ad=2.6p pd=10.52u as=2.6p ps=10.52u w=10u l=0.28u
X81 a_n772_56# a_n836_n8484# a_n932_56# w_n1238_n8602# pfet_03v3 ad=2.6p pd=10.52u as=2.6p ps=10.52u w=10u l=0.28u
X82 a_n772_2168# a_n836_n8484# a_n932_2168# w_n1238_n8602# pfet_03v3 ad=2.6p pd=10.52u as=2.6p ps=10.52u w=10u l=0.28u
X83 a_348_6392# a_284_n8484# a_188_6392# w_n1238_n8602# pfet_03v3 ad=2.6p pd=10.52u as=2.6p ps=10.52u w=10u l=0.28u
X84 a_n612_n8392# a_n676_n8484# a_n772_n8392# w_n1238_n8602# pfet_03v3 ad=2.6p pd=10.52u as=2.6p ps=10.52u w=10u l=0.28u
X85 a_348_4280# a_284_n8484# a_188_4280# w_n1238_n8602# pfet_03v3 ad=2.6p pd=10.52u as=2.6p ps=10.52u w=10u l=0.28u
X86 a_28_6392# a_n36_n8484# a_n132_6392# w_n1238_n8602# pfet_03v3 ad=2.6p pd=10.52u as=2.6p ps=10.52u w=10u l=0.28u
X87 a_188_6392# a_124_n8484# a_28_6392# w_n1238_n8602# pfet_03v3 ad=2.6p pd=10.52u as=2.6p ps=10.52u w=10u l=0.28u
X88 a_28_4280# a_n36_n8484# a_n132_4280# w_n1238_n8602# pfet_03v3 ad=2.6p pd=10.52u as=2.6p ps=10.52u w=10u l=0.28u
X89 a_188_4280# a_124_n8484# a_28_4280# w_n1238_n8602# pfet_03v3 ad=2.6p pd=10.52u as=2.6p ps=10.52u w=10u l=0.28u
X90 a_988_6392# a_924_n8484# a_828_6392# w_n1238_n8602# pfet_03v3 ad=4.33565p pd=20.88u as=2.6p ps=10.52u w=10u l=0.28u
X91 a_828_2168# a_764_n8484# a_668_2168# w_n1238_n8602# pfet_03v3 ad=2.6p pd=10.52u as=2.6p ps=10.52u w=10u l=0.28u
X92 a_988_4280# a_924_n8484# a_828_4280# w_n1238_n8602# pfet_03v3 ad=4.33565p pd=20.88u as=2.6p ps=10.52u w=10u l=0.28u
X93 a_668_2168# a_604_n8484# a_508_2168# w_n1238_n8602# pfet_03v3 ad=2.6p pd=10.52u as=2.6p ps=10.52u w=10u l=0.28u
X94 a_348_n8392# a_284_n8484# a_188_n8392# w_n1238_n8602# pfet_03v3 ad=2.6p pd=10.52u as=2.6p ps=10.52u w=10u l=0.28u
X95 a_n132_6392# a_n196_n8484# a_n292_6392# w_n1238_n8602# pfet_03v3 ad=2.6p pd=10.52u as=2.6p ps=10.52u w=10u l=0.28u
X96 a_828_n8392# a_764_n8484# a_668_n8392# w_n1238_n8602# pfet_03v3 ad=2.6p pd=10.52u as=2.6p ps=10.52u w=10u l=0.28u
X97 a_508_56# a_444_n8484# a_348_56# w_n1238_n8602# pfet_03v3 ad=2.6p pd=10.52u as=2.6p ps=10.52u w=10u l=0.28u
X98 a_n132_4280# a_n196_n8484# a_n292_4280# w_n1238_n8602# pfet_03v3 ad=2.6p pd=10.52u as=2.6p ps=10.52u w=10u l=0.28u
X99 a_n612_56# a_n676_n8484# a_n772_56# w_n1238_n8602# pfet_03v3 ad=2.6p pd=10.52u as=2.6p ps=10.52u w=10u l=0.28u
X100 a_n932_6392# a_n996_n8484# a_n1076_6491# w_n1238_n8602# pfet_03v3 ad=2.6p pd=10.52u as=4.33565p ps=20.88u w=10u l=0.28u
X101 a_n932_4280# a_n996_n8484# a_n1076_4379# w_n1238_n8602# pfet_03v3 ad=2.6p pd=10.52u as=4.33565p ps=20.88u w=10u l=0.28u
X102 a_n932_n8392# a_n996_n8484# a_n1076_n8293# w_n1238_n8602# pfet_03v3 ad=2.6p pd=10.52u as=4.33565p ps=20.88u w=10u l=0.28u
X103 a_28_56# a_n36_n8484# a_n132_56# w_n1238_n8602# pfet_03v3 ad=2.6p pd=10.52u as=2.6p ps=10.52u w=10u l=0.28u
.ends

.subckt gf180mcu_as_sc_mcu7t3v3__fillcap_4 VDD VNW VPW VSS
X0 a_126_408# a_28_500# VSS VPW nfet_03v3 ad=0.44p pd=2.88u as=0.49p ps=2.98u w=1u l=1.03u
X1 VDD a_126_408# a_28_500# VNW pfet_03v3 ad=0.4752p pd=3.04u as=0.5292p ps=3.14u w=1.08u l=1.03u
.ends

.subckt gf180mcu_as_sc_mcu7t3v3__diode_2 VDD VNW VPW VSS DIODE
D0 DIODE VNW diode_pd2nw_03v3 pj=1.93u area=0.2295p
D1 VPW DIODE diode_nd2ps_03v3 pj=1.83u area=0.209p
.ends

.subckt gf180mcu_as_sc_mcu7t3v3__inv_2 VDD VNW VPW VSS Y A
X0 VDD A Y VNW pfet_03v3 ad=0.6072p pd=3.64u as=0.3588p ps=1.9u w=1.38u l=0.28u
X1 Y A VSS VPW nfet_03v3 ad=0.26p pd=1.52u as=0.44p ps=2.88u w=1u l=0.28u
X2 Y A VDD VNW pfet_03v3 ad=0.3588p pd=1.9u as=0.6072p ps=3.64u w=1.38u l=0.28u
X3 VSS A Y VPW nfet_03v3 ad=0.44p pd=2.88u as=0.26p ps=1.52u w=1u l=0.28u
.ends

.subckt gate_drive_3v3 in out dvss dvdd
Xgf180mcu_as_sc_mcu7t3v3__fillcap_4_0 dvdd dvdd dvss dvss gf180mcu_as_sc_mcu7t3v3__fillcap_4
Xgf180mcu_as_sc_mcu7t3v3__fillcap_4_1 dvdd dvdd dvss dvss gf180mcu_as_sc_mcu7t3v3__fillcap_4
Xgf180mcu_as_sc_mcu7t3v3__diode_2_0 dvdd dvdd dvss dvss in gf180mcu_as_sc_mcu7t3v3__diode_2
Xgf180mcu_as_sc_mcu7t3v3__inv_2_1 dvdd dvdd dvss dvss gf180mcu_as_sc_mcu7t3v3__inv_2_1/Y
+ in gf180mcu_as_sc_mcu7t3v3__inv_2
X0 out a_152_4646# dvss dvss nfet_03v3 ad=0.26p pd=1.52u as=0.26p ps=1.52u w=1u l=0.28u
X1 dvdd gf180mcu_as_sc_mcu7t3v3__inv_2_1/Y a_152_4646# dvdd pfet_03v3 ad=0.3588p pd=1.9u as=0.3588p ps=1.9u w=1.38u l=0.28u
X2 dvdd a_152_4646# out dvdd pfet_03v3 ad=0.3588p pd=1.9u as=0.3588p ps=1.9u w=1.38u l=0.28u
X3 dvdd a_152_4646# out dvdd pfet_03v3 ad=0.3588p pd=1.9u as=0.3588p ps=1.9u w=1.38u l=0.28u
X4 a_152_4646# gf180mcu_as_sc_mcu7t3v3__inv_2_1/Y dvdd dvdd pfet_03v3 ad=0.3588p pd=1.9u as=0.3588p ps=1.9u w=1.38u l=0.28u
X5 dvss a_152_4646# out dvss nfet_03v3 ad=0.26p pd=1.52u as=0.26p ps=1.52u w=1u l=0.28u
X6 dvss a_152_4646# out dvss nfet_03v3 ad=0.26p pd=1.52u as=0.26p ps=1.52u w=1u l=0.28u
X7 dvdd gf180mcu_as_sc_mcu7t3v3__inv_2_1/Y a_152_4646# dvdd pfet_03v3 ad=0.9384p pd=4.12u as=0.3588p ps=1.9u w=1.38u l=0.28u
X8 out a_152_4646# dvdd dvdd pfet_03v3 ad=0.3588p pd=1.9u as=0.3588p ps=1.9u w=1.38u l=0.28u
X9 out a_152_4646# dvss dvss nfet_03v3 ad=0.26p pd=1.52u as=0.26p ps=1.52u w=1u l=0.28u
X10 out a_152_4646# dvss dvss nfet_03v3 ad=0.26p pd=1.52u as=0.26p ps=1.52u w=1u l=0.28u
X11 dvdd a_152_4646# out dvdd pfet_03v3 ad=0.3588p pd=1.9u as=0.3588p ps=1.9u w=1.38u l=0.28u
X12 out a_152_4646# dvdd dvdd pfet_03v3 ad=0.3588p pd=1.9u as=0.3588p ps=1.9u w=1.38u l=0.28u
X13 dvss a_152_4646# out dvss nfet_03v3 ad=0.26p pd=1.52u as=0.26p ps=1.52u w=1u l=0.28u
X14 dvdd a_152_4646# out dvdd pfet_03v3 ad=0.3588p pd=1.9u as=0.3588p ps=1.9u w=1.38u l=0.28u
X15 out a_152_4646# dvdd dvdd pfet_03v3 ad=0.3588p pd=1.9u as=0.6072p ps=3.64u w=1.38u l=0.28u
X16 out a_152_4646# dvdd dvdd pfet_03v3 ad=0.3588p pd=1.9u as=0.3588p ps=1.9u w=1.38u l=0.28u
X17 out a_152_4646# dvss dvss nfet_03v3 ad=0.26p pd=1.52u as=0.26p ps=1.52u w=1u l=0.28u
X18 dvdd a_152_4646# out dvdd pfet_03v3 ad=0.3588p pd=1.9u as=0.3588p ps=1.9u w=1.38u l=0.28u
X19 dvss gf180mcu_as_sc_mcu7t3v3__inv_2_1/Y a_152_4646# dvss nfet_03v3 ad=0.26p pd=1.52u as=0.26p ps=1.52u w=1u l=0.28u
X20 dvss a_152_4646# out dvss nfet_03v3 ad=0.26p pd=1.52u as=0.26p ps=1.52u w=1u l=0.28u
X21 out a_152_4646# dvdd dvdd pfet_03v3 ad=0.3588p pd=1.9u as=0.3588p ps=1.9u w=1.38u l=0.28u
X22 a_152_4646# gf180mcu_as_sc_mcu7t3v3__inv_2_1/Y dvss dvss nfet_03v3 ad=0.26p pd=1.52u as=0.26p ps=1.52u w=1u l=0.28u
X23 dvss a_152_4646# out dvss nfet_03v3 ad=0.26p pd=1.52u as=0.26p ps=1.52u w=1u l=0.28u
X24 a_152_4646# gf180mcu_as_sc_mcu7t3v3__inv_2_1/Y dvdd dvdd pfet_03v3 ad=0.3588p pd=1.9u as=0.6072p ps=3.64u w=1.38u l=0.28u
X25 out a_152_4646# dvdd dvdd pfet_03v3 ad=0.3588p pd=1.9u as=0.3588p ps=1.9u w=1.38u l=0.28u
X26 out a_152_4646# dvss dvss nfet_03v3 ad=0.26p pd=1.52u as=0.26p ps=1.52u w=1u l=0.28u
X27 dvdd gf180mcu_as_sc_mcu7t3v3__inv_2_1/Y a_152_4646# dvdd pfet_03v3 ad=0.3588p pd=1.9u as=0.3588p ps=1.9u w=1.38u l=0.28u
X28 a_152_4646# gf180mcu_as_sc_mcu7t3v3__inv_2_1/Y dvdd dvdd pfet_03v3 ad=0.3588p pd=1.9u as=0.3588p ps=1.9u w=1.38u l=0.28u
X29 dvdd a_152_4646# out dvdd pfet_03v3 ad=0.3588p pd=1.9u as=0.3588p ps=1.9u w=1.38u l=0.28u
X30 dvss a_152_4646# out dvss nfet_03v3 ad=0.26p pd=1.52u as=0.26p ps=1.52u w=1u l=0.28u
X31 out a_152_4646# dvss dvss nfet_03v3 ad=0.26p pd=1.52u as=0.26p ps=1.52u w=1u l=0.28u
X32 out a_152_4646# dvdd dvdd pfet_03v3 ad=0.3588p pd=1.9u as=0.3588p ps=1.9u w=1.38u l=0.28u
X33 out a_152_4646# dvdd dvdd pfet_03v3 ad=0.3588p pd=1.9u as=0.3588p ps=1.9u w=1.38u l=0.28u
X34 out a_152_4646# dvss dvss nfet_03v3 ad=0.26p pd=1.52u as=0.26p ps=1.52u w=1u l=0.28u
X35 dvss a_152_4646# out dvss nfet_03v3 ad=0.26p pd=1.52u as=0.26p ps=1.52u w=1u l=0.28u
X36 dvss a_152_4646# out dvss nfet_03v3 ad=0.26p pd=1.52u as=0.26p ps=1.52u w=1u l=0.28u
X37 dvss a_152_4646# out dvss nfet_03v3 ad=0.26p pd=1.52u as=0.26p ps=1.52u w=1u l=0.28u
X38 dvdd a_152_4646# out dvdd pfet_03v3 ad=0.3588p pd=1.9u as=0.3588p ps=1.9u w=1.38u l=0.28u
X39 dvdd a_152_4646# out dvdd pfet_03v3 ad=0.3588p pd=1.9u as=0.3588p ps=1.9u w=1.38u l=0.28u
X40 dvss a_152_4646# out dvss nfet_03v3 ad=0.68p pd=3.36u as=0.26p ps=1.52u w=1u l=0.28u
X41 out a_152_4646# dvdd dvdd pfet_03v3 ad=0.3588p pd=1.9u as=0.3588p ps=1.9u w=1.38u l=0.28u
X42 out a_152_4646# dvdd dvdd pfet_03v3 ad=0.3588p pd=1.9u as=0.3588p ps=1.9u w=1.38u l=0.28u
X43 out a_152_4646# dvss dvss nfet_03v3 ad=0.26p pd=1.52u as=0.26p ps=1.52u w=1u l=0.28u
X44 out a_152_4646# dvss dvss nfet_03v3 ad=0.26p pd=1.52u as=0.26p ps=1.52u w=1u l=0.28u
X45 dvdd a_152_4646# out dvdd pfet_03v3 ad=0.3588p pd=1.9u as=0.3588p ps=1.9u w=1.38u l=0.28u
X46 dvss gf180mcu_as_sc_mcu7t3v3__inv_2_1/Y a_152_4646# dvss nfet_03v3 ad=0.26p pd=1.52u as=0.26p ps=1.52u w=1u l=0.28u
X47 dvss a_152_4646# out dvss nfet_03v3 ad=0.26p pd=1.52u as=0.26p ps=1.52u w=1u l=0.28u
X48 dvss a_152_4646# out dvss nfet_03v3 ad=0.26p pd=1.52u as=0.26p ps=1.52u w=1u l=0.28u
X49 a_152_4646# gf180mcu_as_sc_mcu7t3v3__inv_2_1/Y dvss dvss nfet_03v3 ad=0.26p pd=1.52u as=0.26p ps=1.52u w=1u l=0.28u
X50 out a_152_4646# dvss dvss nfet_03v3 ad=0.26p pd=1.52u as=0.26p ps=1.52u w=1u l=0.28u
X51 out a_152_4646# dvdd dvdd pfet_03v3 ad=0.3588p pd=1.9u as=0.3588p ps=1.9u w=1.38u l=0.28u
X52 dvss gf180mcu_as_sc_mcu7t3v3__inv_2_1/Y a_152_4646# dvss nfet_03v3 ad=0.68p pd=3.36u as=0.26p ps=1.52u w=1u l=0.28u
X53 out a_152_4646# dvss dvss nfet_03v3 ad=0.26p pd=1.52u as=0.26p ps=1.52u w=1u l=0.28u
X54 dvdd gf180mcu_as_sc_mcu7t3v3__inv_2_1/Y a_152_4646# dvdd pfet_03v3 ad=0.3588p pd=1.9u as=0.3588p ps=1.9u w=1.38u l=0.28u
X55 dvdd a_152_4646# out dvdd pfet_03v3 ad=0.3588p pd=1.9u as=0.3588p ps=1.9u w=1.38u l=0.28u
X56 dvss a_152_4646# out dvss nfet_03v3 ad=0.26p pd=1.52u as=0.26p ps=1.52u w=1u l=0.28u
X57 a_152_4646# gf180mcu_as_sc_mcu7t3v3__inv_2_1/Y dvdd dvdd pfet_03v3 ad=0.3588p pd=1.9u as=0.3588p ps=1.9u w=1.38u l=0.28u
X58 dvdd a_152_4646# out dvdd pfet_03v3 ad=0.3588p pd=1.9u as=0.3588p ps=1.9u w=1.38u l=0.28u
X59 dvss a_152_4646# out dvss nfet_03v3 ad=0.26p pd=1.52u as=0.26p ps=1.52u w=1u l=0.28u
X60 out a_152_4646# dvdd dvdd pfet_03v3 ad=0.3588p pd=1.9u as=0.3588p ps=1.9u w=1.38u l=0.28u
X61 out a_152_4646# dvss dvss nfet_03v3 ad=0.26p pd=1.52u as=0.44p ps=2.88u w=1u l=0.28u
X62 out a_152_4646# dvss dvss nfet_03v3 ad=0.26p pd=1.52u as=0.26p ps=1.52u w=1u l=0.28u
X63 dvdd a_152_4646# out dvdd pfet_03v3 ad=0.3588p pd=1.9u as=0.3588p ps=1.9u w=1.38u l=0.28u
X64 dvss a_152_4646# out dvss nfet_03v3 ad=0.26p pd=1.52u as=0.26p ps=1.52u w=1u l=0.28u
X65 out a_152_4646# dvdd dvdd pfet_03v3 ad=0.3588p pd=1.9u as=0.3588p ps=1.9u w=1.38u l=0.28u
X66 a_152_4646# gf180mcu_as_sc_mcu7t3v3__inv_2_1/Y dvss dvss nfet_03v3 ad=0.26p pd=1.52u as=0.44p ps=2.88u w=1u l=0.28u
X67 out a_152_4646# dvss dvss nfet_03v3 ad=0.26p pd=1.52u as=0.26p ps=1.52u w=1u l=0.28u
X68 out a_152_4646# dvdd dvdd pfet_03v3 ad=0.3588p pd=1.9u as=0.3588p ps=1.9u w=1.38u l=0.28u
X69 out a_152_4646# dvss dvss nfet_03v3 ad=0.26p pd=1.52u as=0.26p ps=1.52u w=1u l=0.28u
X70 dvdd a_152_4646# out dvdd pfet_03v3 ad=0.3588p pd=1.9u as=0.3588p ps=1.9u w=1.38u l=0.28u
X71 dvdd a_152_4646# out dvdd pfet_03v3 ad=0.3588p pd=1.9u as=0.3588p ps=1.9u w=1.38u l=0.28u
X72 dvss gf180mcu_as_sc_mcu7t3v3__inv_2_1/Y a_152_4646# dvss nfet_03v3 ad=0.26p pd=1.52u as=0.26p ps=1.52u w=1u l=0.28u
X73 dvss a_152_4646# out dvss nfet_03v3 ad=0.26p pd=1.52u as=0.26p ps=1.52u w=1u l=0.28u
X74 dvdd a_152_4646# out dvdd pfet_03v3 ad=0.3588p pd=1.9u as=0.3588p ps=1.9u w=1.38u l=0.28u
X75 dvdd a_152_4646# out dvdd pfet_03v3 ad=0.9384p pd=4.12u as=0.3588p ps=1.9u w=1.38u l=0.28u
X76 a_152_4646# gf180mcu_as_sc_mcu7t3v3__inv_2_1/Y dvss dvss nfet_03v3 ad=0.26p pd=1.52u as=0.26p ps=1.52u w=1u l=0.28u
X77 out a_152_4646# dvdd dvdd pfet_03v3 ad=0.3588p pd=1.9u as=0.3588p ps=1.9u w=1.38u l=0.28u
X78 out a_152_4646# dvdd dvdd pfet_03v3 ad=0.3588p pd=1.9u as=0.3588p ps=1.9u w=1.38u l=0.28u
X79 out a_152_4646# dvss dvss nfet_03v3 ad=0.26p pd=1.52u as=0.26p ps=1.52u w=1u l=0.28u
.ends

.subckt power_stage3v3 DVDD_IN DVDD_OUT DVSS enable
Xpfet_03v3_GVZKMY_0[0] DVDD_OUT DVDD_IN gate_drive_3v3_0/out DVDD_IN DVDD_OUT DVDD_IN
+ DVDD_IN DVDD_IN DVDD_OUT DVDD_IN DVDD_OUT DVDD_OUT DVDD_OUT DVDD_OUT DVDD_IN DVDD_IN
+ DVDD_OUT DVDD_OUT DVDD_OUT gate_drive_3v3_0/out DVDD_OUT DVDD_IN DVDD_IN DVDD_OUT
+ DVDD_IN DVDD_OUT DVDD_IN DVDD_OUT DVDD_IN DVDD_IN DVDD_OUT DVDD_IN DVDD_OUT DVDD_OUT
+ DVDD_IN DVDD_IN DVDD_OUT DVDD_OUT gate_drive_3v3_0/out gate_drive_3v3_0/out DVDD_IN
+ DVDD_IN gate_drive_3v3_0/out DVDD_IN DVDD_OUT DVDD_IN DVDD_OUT DVDD_OUT DVDD_OUT
+ DVDD_IN DVDD_OUT DVDD_IN DVDD_IN DVDD_IN DVDD_OUT DVDD_OUT DVDD_IN DVDD_IN DVDD_IN
+ DVDD_OUT DVDD_OUT DVDD_IN DVDD_OUT DVDD_OUT DVDD_IN gate_drive_3v3_0/out DVDD_OUT
+ DVDD_OUT DVDD_IN DVDD_IN DVDD_IN DVDD_OUT gate_drive_3v3_0/out DVDD_OUT DVDD_IN
+ DVDD_IN DVDD_IN DVDD_OUT DVDD_OUT DVDD_IN DVDD_IN DVDD_OUT DVDD_OUT DVDD_IN DVDD_OUT
+ DVDD_OUT DVDD_IN DVDD_OUT DVDD_OUT DVDD_IN gate_drive_3v3_0/out DVDD_IN gate_drive_3v3_0/out
+ DVDD_IN DVDD_IN DVDD_IN DVDD_OUT DVDD_IN DVDD_OUT DVDD_OUT DVDD_IN DVDD_IN DVDD_IN
+ DVDD_OUT DVDD_OUT DVDD_OUT DVDD_OUT gate_drive_3v3_0/out gate_drive_3v3_0/out DVDD_IN
+ DVDD_OUT DVDD_IN DVDD_OUT DVDD_IN DVDD_IN DVDD_IN DVDD_IN DVDD_IN gate_drive_3v3_0/out
+ DVDD_OUT DVDD_IN gate_drive_3v3_0/out DVDD_OUT DVDD_OUT DVDD_OUT DVDD_OUT pfet_03v3_GVZKMY
Xpfet_03v3_GVZKMY_0[1] DVDD_OUT DVDD_IN gate_drive_3v3_0/out DVDD_IN DVDD_OUT DVDD_IN
+ DVDD_IN DVDD_IN DVDD_OUT DVDD_IN DVDD_OUT DVDD_OUT DVDD_OUT DVDD_OUT DVDD_IN DVDD_IN
+ DVDD_OUT DVDD_OUT DVDD_OUT gate_drive_3v3_0/out DVDD_OUT DVDD_IN DVDD_IN DVDD_OUT
+ DVDD_IN DVDD_OUT DVDD_IN DVDD_OUT DVDD_IN DVDD_IN DVDD_OUT DVDD_IN DVDD_OUT DVDD_OUT
+ DVDD_IN DVDD_IN DVDD_OUT DVDD_OUT gate_drive_3v3_0/out gate_drive_3v3_0/out DVDD_IN
+ DVDD_IN gate_drive_3v3_0/out DVDD_IN DVDD_OUT DVDD_IN DVDD_OUT DVDD_OUT DVDD_OUT
+ DVDD_IN DVDD_OUT DVDD_IN DVDD_IN DVDD_IN DVDD_OUT DVDD_OUT DVDD_IN DVDD_IN DVDD_IN
+ DVDD_OUT DVDD_OUT DVDD_IN DVDD_OUT DVDD_OUT DVDD_IN gate_drive_3v3_0/out DVDD_OUT
+ DVDD_OUT DVDD_IN DVDD_IN DVDD_IN DVDD_OUT gate_drive_3v3_0/out DVDD_OUT DVDD_IN
+ DVDD_IN DVDD_IN DVDD_OUT DVDD_OUT DVDD_IN DVDD_IN DVDD_OUT DVDD_OUT DVDD_IN DVDD_OUT
+ DVDD_OUT DVDD_IN DVDD_OUT DVDD_OUT DVDD_IN gate_drive_3v3_0/out DVDD_IN gate_drive_3v3_0/out
+ DVDD_IN DVDD_IN DVDD_IN DVDD_OUT DVDD_IN DVDD_OUT DVDD_OUT DVDD_IN DVDD_IN DVDD_IN
+ DVDD_OUT DVDD_OUT DVDD_OUT DVDD_OUT gate_drive_3v3_0/out gate_drive_3v3_0/out DVDD_IN
+ DVDD_OUT DVDD_IN DVDD_OUT DVDD_IN DVDD_IN DVDD_IN DVDD_IN DVDD_IN gate_drive_3v3_0/out
+ DVDD_OUT DVDD_IN gate_drive_3v3_0/out DVDD_OUT DVDD_OUT DVDD_OUT DVDD_OUT pfet_03v3_GVZKMY
Xpfet_03v3_GVZKMY_0[2] DVDD_OUT DVDD_IN gate_drive_3v3_0/out DVDD_IN DVDD_OUT DVDD_IN
+ DVDD_IN DVDD_IN DVDD_OUT DVDD_IN DVDD_OUT DVDD_OUT DVDD_OUT DVDD_OUT DVDD_IN DVDD_IN
+ DVDD_OUT DVDD_OUT DVDD_OUT gate_drive_3v3_0/out DVDD_OUT DVDD_IN DVDD_IN DVDD_OUT
+ DVDD_IN DVDD_OUT DVDD_IN DVDD_OUT DVDD_IN DVDD_IN DVDD_OUT DVDD_IN DVDD_OUT DVDD_OUT
+ DVDD_IN DVDD_IN DVDD_OUT DVDD_OUT gate_drive_3v3_0/out gate_drive_3v3_0/out DVDD_IN
+ DVDD_IN gate_drive_3v3_0/out DVDD_IN DVDD_OUT DVDD_IN DVDD_OUT DVDD_OUT DVDD_OUT
+ DVDD_IN DVDD_OUT DVDD_IN DVDD_IN DVDD_IN DVDD_OUT DVDD_OUT DVDD_IN DVDD_IN DVDD_IN
+ DVDD_OUT DVDD_OUT DVDD_IN DVDD_OUT DVDD_OUT DVDD_IN gate_drive_3v3_0/out DVDD_OUT
+ DVDD_OUT DVDD_IN DVDD_IN DVDD_IN DVDD_OUT gate_drive_3v3_0/out DVDD_OUT DVDD_IN
+ DVDD_IN DVDD_IN DVDD_OUT DVDD_OUT DVDD_IN DVDD_IN DVDD_OUT DVDD_OUT DVDD_IN DVDD_OUT
+ DVDD_OUT DVDD_IN DVDD_OUT DVDD_OUT DVDD_IN gate_drive_3v3_0/out DVDD_IN gate_drive_3v3_0/out
+ DVDD_IN DVDD_IN DVDD_IN DVDD_OUT DVDD_IN DVDD_OUT DVDD_OUT DVDD_IN DVDD_IN DVDD_IN
+ DVDD_OUT DVDD_OUT DVDD_OUT DVDD_OUT gate_drive_3v3_0/out gate_drive_3v3_0/out DVDD_IN
+ DVDD_OUT DVDD_IN DVDD_OUT DVDD_IN DVDD_IN DVDD_IN DVDD_IN DVDD_IN gate_drive_3v3_0/out
+ DVDD_OUT DVDD_IN gate_drive_3v3_0/out DVDD_OUT DVDD_OUT DVDD_OUT DVDD_OUT pfet_03v3_GVZKMY
Xpfet_03v3_GVZKMY_0[3] DVDD_OUT DVDD_IN gate_drive_3v3_0/out DVDD_IN DVDD_OUT DVDD_IN
+ DVDD_IN DVDD_IN DVDD_OUT DVDD_IN DVDD_OUT DVDD_OUT DVDD_OUT DVDD_OUT DVDD_IN DVDD_IN
+ DVDD_OUT DVDD_OUT DVDD_OUT gate_drive_3v3_0/out DVDD_OUT DVDD_IN DVDD_IN DVDD_OUT
+ DVDD_IN DVDD_OUT DVDD_IN DVDD_OUT DVDD_IN DVDD_IN DVDD_OUT DVDD_IN DVDD_OUT DVDD_OUT
+ DVDD_IN DVDD_IN DVDD_OUT DVDD_OUT gate_drive_3v3_0/out gate_drive_3v3_0/out DVDD_IN
+ DVDD_IN gate_drive_3v3_0/out DVDD_IN DVDD_OUT DVDD_IN DVDD_OUT DVDD_OUT DVDD_OUT
+ DVDD_IN DVDD_OUT DVDD_IN DVDD_IN DVDD_IN DVDD_OUT DVDD_OUT DVDD_IN DVDD_IN DVDD_IN
+ DVDD_OUT DVDD_OUT DVDD_IN DVDD_OUT DVDD_OUT DVDD_IN gate_drive_3v3_0/out DVDD_OUT
+ DVDD_OUT DVDD_IN DVDD_IN DVDD_IN DVDD_OUT gate_drive_3v3_0/out DVDD_OUT DVDD_IN
+ DVDD_IN DVDD_IN DVDD_OUT DVDD_OUT DVDD_IN DVDD_IN DVDD_OUT DVDD_OUT DVDD_IN DVDD_OUT
+ DVDD_OUT DVDD_IN DVDD_OUT DVDD_OUT DVDD_IN gate_drive_3v3_0/out DVDD_IN gate_drive_3v3_0/out
+ DVDD_IN DVDD_IN DVDD_IN DVDD_OUT DVDD_IN DVDD_OUT DVDD_OUT DVDD_IN DVDD_IN DVDD_IN
+ DVDD_OUT DVDD_OUT DVDD_OUT DVDD_OUT gate_drive_3v3_0/out gate_drive_3v3_0/out DVDD_IN
+ DVDD_OUT DVDD_IN DVDD_OUT DVDD_IN DVDD_IN DVDD_IN DVDD_IN DVDD_IN gate_drive_3v3_0/out
+ DVDD_OUT DVDD_IN gate_drive_3v3_0/out DVDD_OUT DVDD_OUT DVDD_OUT DVDD_OUT pfet_03v3_GVZKMY
Xpfet_03v3_GVZKMY_0[4] DVDD_OUT DVDD_IN gate_drive_3v3_0/out DVDD_IN DVDD_OUT DVDD_IN
+ DVDD_IN DVDD_IN DVDD_OUT DVDD_IN DVDD_OUT DVDD_OUT DVDD_OUT DVDD_OUT DVDD_IN DVDD_IN
+ DVDD_OUT DVDD_OUT DVDD_OUT gate_drive_3v3_0/out DVDD_OUT DVDD_IN DVDD_IN DVDD_OUT
+ DVDD_IN DVDD_OUT DVDD_IN DVDD_OUT DVDD_IN DVDD_IN DVDD_OUT DVDD_IN DVDD_OUT DVDD_OUT
+ DVDD_IN DVDD_IN DVDD_OUT DVDD_OUT gate_drive_3v3_0/out gate_drive_3v3_0/out DVDD_IN
+ DVDD_IN gate_drive_3v3_0/out DVDD_IN DVDD_OUT DVDD_IN DVDD_OUT DVDD_OUT DVDD_OUT
+ DVDD_IN DVDD_OUT DVDD_IN DVDD_IN DVDD_IN DVDD_OUT DVDD_OUT DVDD_IN DVDD_IN DVDD_IN
+ DVDD_OUT DVDD_OUT DVDD_IN DVDD_OUT DVDD_OUT DVDD_IN gate_drive_3v3_0/out DVDD_OUT
+ DVDD_OUT DVDD_IN DVDD_IN DVDD_IN DVDD_OUT gate_drive_3v3_0/out DVDD_OUT DVDD_IN
+ DVDD_IN DVDD_IN DVDD_OUT DVDD_OUT DVDD_IN DVDD_IN DVDD_OUT DVDD_OUT DVDD_IN DVDD_OUT
+ DVDD_OUT DVDD_IN DVDD_OUT DVDD_OUT DVDD_IN gate_drive_3v3_0/out DVDD_IN gate_drive_3v3_0/out
+ DVDD_IN DVDD_IN DVDD_IN DVDD_OUT DVDD_IN DVDD_OUT DVDD_OUT DVDD_IN DVDD_IN DVDD_IN
+ DVDD_OUT DVDD_OUT DVDD_OUT DVDD_OUT gate_drive_3v3_0/out gate_drive_3v3_0/out DVDD_IN
+ DVDD_OUT DVDD_IN DVDD_OUT DVDD_IN DVDD_IN DVDD_IN DVDD_IN DVDD_IN gate_drive_3v3_0/out
+ DVDD_OUT DVDD_IN gate_drive_3v3_0/out DVDD_OUT DVDD_OUT DVDD_OUT DVDD_OUT pfet_03v3_GVZKMY
Xgate_drive_3v3_0 enable gate_drive_3v3_0/out DVSS DVDD_IN gate_drive_3v3
.ends
